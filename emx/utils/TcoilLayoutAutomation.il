load("/autofs/fs1.ece/fs1.eecg.tcc/lizongh2/gf22x-1020b/myskill/CCSchangeParam.il")
load("/autofs/fs1.ece/fs1.eecg.tcc/lizongh2/gf22x-1020b/myskill/MovePinsToInstances.il")
load("/autofs/fs1.ece/fs1.eecg.tcc/lizongh2/gf22x-1020b/myskill/StreamOutGDS.il")

cv_schematic = dbOpenCellViewByType("tcoil" "tcoil_master" "schematic")
CCSchangeParam( "tcoil" "tcoil_master" "schematic" "tcoil3_mmw" "pneo" "60" )
CCSchangeParam( "tcoil" "tcoil_master" "schematic" "tcoil3_mmw" "ctapLocation" "bot" )
CCSchangeParam( "tcoil" "tcoil_master" "schematic" "tcoil3_mmw" "od" "32u" )
CCSchangeParam( "tcoil" "tcoil_master" "schematic" "tcoil3_mmw" "w" "2.4u" )
CCSchangeParam( "tcoil" "tcoil_master" "schematic" "tcoil3_mmw" "neo" "4" )
CCSchangeParam( "tcoil" "tcoil_master" "schematic" "tcoil3_mmw" "nei" "5" )
lxGenFromSource( cv_schematic )
cv_layout = dbOpenCellViewByType("tcoil" "tcoil_master" "layout")
MovePinsToInstances( cv_schematic cv_layout )
StreamOutGDS("tcoil" "tcoil_master" "layout" "/autofs/fs1.ece/fs1.eecg.tcc/lizongh2/gf22x-1020b/EMX_work/tcoil_tcoil2570.work" "tcoil2570.gds")

cv_schematic = dbOpenCellViewByType("tcoil" "tcoil_master" "schematic")
CCSchangeParam( "tcoil" "tcoil_master" "schematic" "tcoil3_mmw" "pneo" "60" )
CCSchangeParam( "tcoil" "tcoil_master" "schematic" "tcoil3_mmw" "ctapLocation" "bot" )
CCSchangeParam( "tcoil" "tcoil_master" "schematic" "tcoil3_mmw" "od" "32u" )
CCSchangeParam( "tcoil" "tcoil_master" "schematic" "tcoil3_mmw" "w" "2.4u" )
CCSchangeParam( "tcoil" "tcoil_master" "schematic" "tcoil3_mmw" "neo" "6" )
CCSchangeParam( "tcoil" "tcoil_master" "schematic" "tcoil3_mmw" "nei" "5" )
lxGenFromSource( cv_schematic )
cv_layout = dbOpenCellViewByType("tcoil" "tcoil_master" "layout")
MovePinsToInstances( cv_schematic cv_layout )
StreamOutGDS("tcoil" "tcoil_master" "layout" "/autofs/fs1.ece/fs1.eecg.tcc/lizongh2/gf22x-1020b/EMX_work/tcoil_tcoil2571.work" "tcoil2571.gds")

cv_schematic = dbOpenCellViewByType("tcoil" "tcoil_master" "schematic")
CCSchangeParam( "tcoil" "tcoil_master" "schematic" "tcoil3_mmw" "pneo" "60" )
CCSchangeParam( "tcoil" "tcoil_master" "schematic" "tcoil3_mmw" "ctapLocation" "bot" )
CCSchangeParam( "tcoil" "tcoil_master" "schematic" "tcoil3_mmw" "od" "32u" )
CCSchangeParam( "tcoil" "tcoil_master" "schematic" "tcoil3_mmw" "w" "2.4u" )
CCSchangeParam( "tcoil" "tcoil_master" "schematic" "tcoil3_mmw" "neo" "8" )
CCSchangeParam( "tcoil" "tcoil_master" "schematic" "tcoil3_mmw" "nei" "5" )
lxGenFromSource( cv_schematic )
cv_layout = dbOpenCellViewByType("tcoil" "tcoil_master" "layout")
MovePinsToInstances( cv_schematic cv_layout )
StreamOutGDS("tcoil" "tcoil_master" "layout" "/autofs/fs1.ece/fs1.eecg.tcc/lizongh2/gf22x-1020b/EMX_work/tcoil_tcoil2572.work" "tcoil2572.gds")

cv_schematic = dbOpenCellViewByType("tcoil" "tcoil_master" "schematic")
CCSchangeParam( "tcoil" "tcoil_master" "schematic" "tcoil3_mmw" "pneo" "60" )
CCSchangeParam( "tcoil" "tcoil_master" "schematic" "tcoil3_mmw" "ctapLocation" "bot" )
CCSchangeParam( "tcoil" "tcoil_master" "schematic" "tcoil3_mmw" "od" "32u" )
CCSchangeParam( "tcoil" "tcoil_master" "schematic" "tcoil3_mmw" "w" "2.4u" )
CCSchangeParam( "tcoil" "tcoil_master" "schematic" "tcoil3_mmw" "neo" "10" )
CCSchangeParam( "tcoil" "tcoil_master" "schematic" "tcoil3_mmw" "nei" "5" )
lxGenFromSource( cv_schematic )
cv_layout = dbOpenCellViewByType("tcoil" "tcoil_master" "layout")
MovePinsToInstances( cv_schematic cv_layout )
StreamOutGDS("tcoil" "tcoil_master" "layout" "/autofs/fs1.ece/fs1.eecg.tcc/lizongh2/gf22x-1020b/EMX_work/tcoil_tcoil2573.work" "tcoil2573.gds")

cv_schematic = dbOpenCellViewByType("tcoil" "tcoil_master" "schematic")
CCSchangeParam( "tcoil" "tcoil_master" "schematic" "tcoil3_mmw" "pneo" "60" )
CCSchangeParam( "tcoil" "tcoil_master" "schematic" "tcoil3_mmw" "ctapLocation" "bot" )
CCSchangeParam( "tcoil" "tcoil_master" "schematic" "tcoil3_mmw" "od" "32u" )
CCSchangeParam( "tcoil" "tcoil_master" "schematic" "tcoil3_mmw" "w" "2.4u" )
CCSchangeParam( "tcoil" "tcoil_master" "schematic" "tcoil3_mmw" "neo" "12" )
CCSchangeParam( "tcoil" "tcoil_master" "schematic" "tcoil3_mmw" "nei" "5" )
lxGenFromSource( cv_schematic )
cv_layout = dbOpenCellViewByType("tcoil" "tcoil_master" "layout")
MovePinsToInstances( cv_schematic cv_layout )
StreamOutGDS("tcoil" "tcoil_master" "layout" "/autofs/fs1.ece/fs1.eecg.tcc/lizongh2/gf22x-1020b/EMX_work/tcoil_tcoil2574.work" "tcoil2574.gds")

cv_schematic = dbOpenCellViewByType("tcoil" "tcoil_master" "schematic")
CCSchangeParam( "tcoil" "tcoil_master" "schematic" "tcoil3_mmw" "pneo" "60" )
CCSchangeParam( "tcoil" "tcoil_master" "schematic" "tcoil3_mmw" "ctapLocation" "bot" )
CCSchangeParam( "tcoil" "tcoil_master" "schematic" "tcoil3_mmw" "od" "32u" )
CCSchangeParam( "tcoil" "tcoil_master" "schematic" "tcoil3_mmw" "w" "4.2u" )
CCSchangeParam( "tcoil" "tcoil_master" "schematic" "tcoil3_mmw" "neo" "4" )
CCSchangeParam( "tcoil" "tcoil_master" "schematic" "tcoil3_mmw" "nei" "5" )
lxGenFromSource( cv_schematic )
cv_layout = dbOpenCellViewByType("tcoil" "tcoil_master" "layout")
MovePinsToInstances( cv_schematic cv_layout )
StreamOutGDS("tcoil" "tcoil_master" "layout" "/autofs/fs1.ece/fs1.eecg.tcc/lizongh2/gf22x-1020b/EMX_work/tcoil_tcoil2575.work" "tcoil2575.gds")

cv_schematic = dbOpenCellViewByType("tcoil" "tcoil_master" "schematic")
CCSchangeParam( "tcoil" "tcoil_master" "schematic" "tcoil3_mmw" "pneo" "60" )
CCSchangeParam( "tcoil" "tcoil_master" "schematic" "tcoil3_mmw" "ctapLocation" "bot" )
CCSchangeParam( "tcoil" "tcoil_master" "schematic" "tcoil3_mmw" "od" "32u" )
CCSchangeParam( "tcoil" "tcoil_master" "schematic" "tcoil3_mmw" "w" "4.2u" )
CCSchangeParam( "tcoil" "tcoil_master" "schematic" "tcoil3_mmw" "neo" "6" )
CCSchangeParam( "tcoil" "tcoil_master" "schematic" "tcoil3_mmw" "nei" "5" )
lxGenFromSource( cv_schematic )
cv_layout = dbOpenCellViewByType("tcoil" "tcoil_master" "layout")
MovePinsToInstances( cv_schematic cv_layout )
StreamOutGDS("tcoil" "tcoil_master" "layout" "/autofs/fs1.ece/fs1.eecg.tcc/lizongh2/gf22x-1020b/EMX_work/tcoil_tcoil2576.work" "tcoil2576.gds")

cv_schematic = dbOpenCellViewByType("tcoil" "tcoil_master" "schematic")
CCSchangeParam( "tcoil" "tcoil_master" "schematic" "tcoil3_mmw" "pneo" "60" )
CCSchangeParam( "tcoil" "tcoil_master" "schematic" "tcoil3_mmw" "ctapLocation" "bot" )
CCSchangeParam( "tcoil" "tcoil_master" "schematic" "tcoil3_mmw" "od" "32u" )
CCSchangeParam( "tcoil" "tcoil_master" "schematic" "tcoil3_mmw" "w" "4.2u" )
CCSchangeParam( "tcoil" "tcoil_master" "schematic" "tcoil3_mmw" "neo" "8" )
CCSchangeParam( "tcoil" "tcoil_master" "schematic" "tcoil3_mmw" "nei" "5" )
lxGenFromSource( cv_schematic )
cv_layout = dbOpenCellViewByType("tcoil" "tcoil_master" "layout")
MovePinsToInstances( cv_schematic cv_layout )
StreamOutGDS("tcoil" "tcoil_master" "layout" "/autofs/fs1.ece/fs1.eecg.tcc/lizongh2/gf22x-1020b/EMX_work/tcoil_tcoil2577.work" "tcoil2577.gds")

cv_schematic = dbOpenCellViewByType("tcoil" "tcoil_master" "schematic")
CCSchangeParam( "tcoil" "tcoil_master" "schematic" "tcoil3_mmw" "pneo" "60" )
CCSchangeParam( "tcoil" "tcoil_master" "schematic" "tcoil3_mmw" "ctapLocation" "bot" )
CCSchangeParam( "tcoil" "tcoil_master" "schematic" "tcoil3_mmw" "od" "32u" )
CCSchangeParam( "tcoil" "tcoil_master" "schematic" "tcoil3_mmw" "w" "4.2u" )
CCSchangeParam( "tcoil" "tcoil_master" "schematic" "tcoil3_mmw" "neo" "10" )
CCSchangeParam( "tcoil" "tcoil_master" "schematic" "tcoil3_mmw" "nei" "5" )
lxGenFromSource( cv_schematic )
cv_layout = dbOpenCellViewByType("tcoil" "tcoil_master" "layout")
MovePinsToInstances( cv_schematic cv_layout )
StreamOutGDS("tcoil" "tcoil_master" "layout" "/autofs/fs1.ece/fs1.eecg.tcc/lizongh2/gf22x-1020b/EMX_work/tcoil_tcoil2578.work" "tcoil2578.gds")

cv_schematic = dbOpenCellViewByType("tcoil" "tcoil_master" "schematic")
CCSchangeParam( "tcoil" "tcoil_master" "schematic" "tcoil3_mmw" "pneo" "60" )
CCSchangeParam( "tcoil" "tcoil_master" "schematic" "tcoil3_mmw" "ctapLocation" "bot" )
CCSchangeParam( "tcoil" "tcoil_master" "schematic" "tcoil3_mmw" "od" "32u" )
CCSchangeParam( "tcoil" "tcoil_master" "schematic" "tcoil3_mmw" "w" "4.2u" )
CCSchangeParam( "tcoil" "tcoil_master" "schematic" "tcoil3_mmw" "neo" "12" )
CCSchangeParam( "tcoil" "tcoil_master" "schematic" "tcoil3_mmw" "nei" "5" )
lxGenFromSource( cv_schematic )
cv_layout = dbOpenCellViewByType("tcoil" "tcoil_master" "layout")
MovePinsToInstances( cv_schematic cv_layout )
StreamOutGDS("tcoil" "tcoil_master" "layout" "/autofs/fs1.ece/fs1.eecg.tcc/lizongh2/gf22x-1020b/EMX_work/tcoil_tcoil2579.work" "tcoil2579.gds")

cv_schematic = dbOpenCellViewByType("tcoil" "tcoil_master" "schematic")
CCSchangeParam( "tcoil" "tcoil_master" "schematic" "tcoil3_mmw" "pneo" "60" )
CCSchangeParam( "tcoil" "tcoil_master" "schematic" "tcoil3_mmw" "ctapLocation" "bot" )
CCSchangeParam( "tcoil" "tcoil_master" "schematic" "tcoil3_mmw" "od" "34u" )
CCSchangeParam( "tcoil" "tcoil_master" "schematic" "tcoil3_mmw" "w" "2.4u" )
CCSchangeParam( "tcoil" "tcoil_master" "schematic" "tcoil3_mmw" "neo" "4" )
CCSchangeParam( "tcoil" "tcoil_master" "schematic" "tcoil3_mmw" "nei" "5" )
lxGenFromSource( cv_schematic )
cv_layout = dbOpenCellViewByType("tcoil" "tcoil_master" "layout")
MovePinsToInstances( cv_schematic cv_layout )
StreamOutGDS("tcoil" "tcoil_master" "layout" "/autofs/fs1.ece/fs1.eecg.tcc/lizongh2/gf22x-1020b/EMX_work/tcoil_tcoil2580.work" "tcoil2580.gds")

cv_schematic = dbOpenCellViewByType("tcoil" "tcoil_master" "schematic")
CCSchangeParam( "tcoil" "tcoil_master" "schematic" "tcoil3_mmw" "pneo" "60" )
CCSchangeParam( "tcoil" "tcoil_master" "schematic" "tcoil3_mmw" "ctapLocation" "bot" )
CCSchangeParam( "tcoil" "tcoil_master" "schematic" "tcoil3_mmw" "od" "34u" )
CCSchangeParam( "tcoil" "tcoil_master" "schematic" "tcoil3_mmw" "w" "2.4u" )
CCSchangeParam( "tcoil" "tcoil_master" "schematic" "tcoil3_mmw" "neo" "6" )
CCSchangeParam( "tcoil" "tcoil_master" "schematic" "tcoil3_mmw" "nei" "5" )
lxGenFromSource( cv_schematic )
cv_layout = dbOpenCellViewByType("tcoil" "tcoil_master" "layout")
MovePinsToInstances( cv_schematic cv_layout )
StreamOutGDS("tcoil" "tcoil_master" "layout" "/autofs/fs1.ece/fs1.eecg.tcc/lizongh2/gf22x-1020b/EMX_work/tcoil_tcoil2581.work" "tcoil2581.gds")

cv_schematic = dbOpenCellViewByType("tcoil" "tcoil_master" "schematic")
CCSchangeParam( "tcoil" "tcoil_master" "schematic" "tcoil3_mmw" "pneo" "60" )
CCSchangeParam( "tcoil" "tcoil_master" "schematic" "tcoil3_mmw" "ctapLocation" "bot" )
CCSchangeParam( "tcoil" "tcoil_master" "schematic" "tcoil3_mmw" "od" "34u" )
CCSchangeParam( "tcoil" "tcoil_master" "schematic" "tcoil3_mmw" "w" "2.4u" )
CCSchangeParam( "tcoil" "tcoil_master" "schematic" "tcoil3_mmw" "neo" "8" )
CCSchangeParam( "tcoil" "tcoil_master" "schematic" "tcoil3_mmw" "nei" "5" )
lxGenFromSource( cv_schematic )
cv_layout = dbOpenCellViewByType("tcoil" "tcoil_master" "layout")
MovePinsToInstances( cv_schematic cv_layout )
StreamOutGDS("tcoil" "tcoil_master" "layout" "/autofs/fs1.ece/fs1.eecg.tcc/lizongh2/gf22x-1020b/EMX_work/tcoil_tcoil2582.work" "tcoil2582.gds")

cv_schematic = dbOpenCellViewByType("tcoil" "tcoil_master" "schematic")
CCSchangeParam( "tcoil" "tcoil_master" "schematic" "tcoil3_mmw" "pneo" "60" )
CCSchangeParam( "tcoil" "tcoil_master" "schematic" "tcoil3_mmw" "ctapLocation" "bot" )
CCSchangeParam( "tcoil" "tcoil_master" "schematic" "tcoil3_mmw" "od" "34u" )
CCSchangeParam( "tcoil" "tcoil_master" "schematic" "tcoil3_mmw" "w" "2.4u" )
CCSchangeParam( "tcoil" "tcoil_master" "schematic" "tcoil3_mmw" "neo" "10" )
CCSchangeParam( "tcoil" "tcoil_master" "schematic" "tcoil3_mmw" "nei" "5" )
lxGenFromSource( cv_schematic )
cv_layout = dbOpenCellViewByType("tcoil" "tcoil_master" "layout")
MovePinsToInstances( cv_schematic cv_layout )
StreamOutGDS("tcoil" "tcoil_master" "layout" "/autofs/fs1.ece/fs1.eecg.tcc/lizongh2/gf22x-1020b/EMX_work/tcoil_tcoil2583.work" "tcoil2583.gds")

cv_schematic = dbOpenCellViewByType("tcoil" "tcoil_master" "schematic")
CCSchangeParam( "tcoil" "tcoil_master" "schematic" "tcoil3_mmw" "pneo" "60" )
CCSchangeParam( "tcoil" "tcoil_master" "schematic" "tcoil3_mmw" "ctapLocation" "bot" )
CCSchangeParam( "tcoil" "tcoil_master" "schematic" "tcoil3_mmw" "od" "34u" )
CCSchangeParam( "tcoil" "tcoil_master" "schematic" "tcoil3_mmw" "w" "2.4u" )
CCSchangeParam( "tcoil" "tcoil_master" "schematic" "tcoil3_mmw" "neo" "12" )
CCSchangeParam( "tcoil" "tcoil_master" "schematic" "tcoil3_mmw" "nei" "5" )
lxGenFromSource( cv_schematic )
cv_layout = dbOpenCellViewByType("tcoil" "tcoil_master" "layout")
MovePinsToInstances( cv_schematic cv_layout )
StreamOutGDS("tcoil" "tcoil_master" "layout" "/autofs/fs1.ece/fs1.eecg.tcc/lizongh2/gf22x-1020b/EMX_work/tcoil_tcoil2584.work" "tcoil2584.gds")

cv_schematic = dbOpenCellViewByType("tcoil" "tcoil_master" "schematic")
CCSchangeParam( "tcoil" "tcoil_master" "schematic" "tcoil3_mmw" "pneo" "60" )
CCSchangeParam( "tcoil" "tcoil_master" "schematic" "tcoil3_mmw" "ctapLocation" "bot" )
CCSchangeParam( "tcoil" "tcoil_master" "schematic" "tcoil3_mmw" "od" "34u" )
CCSchangeParam( "tcoil" "tcoil_master" "schematic" "tcoil3_mmw" "w" "4.2u" )
CCSchangeParam( "tcoil" "tcoil_master" "schematic" "tcoil3_mmw" "neo" "4" )
CCSchangeParam( "tcoil" "tcoil_master" "schematic" "tcoil3_mmw" "nei" "5" )
lxGenFromSource( cv_schematic )
cv_layout = dbOpenCellViewByType("tcoil" "tcoil_master" "layout")
MovePinsToInstances( cv_schematic cv_layout )
StreamOutGDS("tcoil" "tcoil_master" "layout" "/autofs/fs1.ece/fs1.eecg.tcc/lizongh2/gf22x-1020b/EMX_work/tcoil_tcoil2585.work" "tcoil2585.gds")

cv_schematic = dbOpenCellViewByType("tcoil" "tcoil_master" "schematic")
CCSchangeParam( "tcoil" "tcoil_master" "schematic" "tcoil3_mmw" "pneo" "60" )
CCSchangeParam( "tcoil" "tcoil_master" "schematic" "tcoil3_mmw" "ctapLocation" "bot" )
CCSchangeParam( "tcoil" "tcoil_master" "schematic" "tcoil3_mmw" "od" "34u" )
CCSchangeParam( "tcoil" "tcoil_master" "schematic" "tcoil3_mmw" "w" "4.2u" )
CCSchangeParam( "tcoil" "tcoil_master" "schematic" "tcoil3_mmw" "neo" "6" )
CCSchangeParam( "tcoil" "tcoil_master" "schematic" "tcoil3_mmw" "nei" "5" )
lxGenFromSource( cv_schematic )
cv_layout = dbOpenCellViewByType("tcoil" "tcoil_master" "layout")
MovePinsToInstances( cv_schematic cv_layout )
StreamOutGDS("tcoil" "tcoil_master" "layout" "/autofs/fs1.ece/fs1.eecg.tcc/lizongh2/gf22x-1020b/EMX_work/tcoil_tcoil2586.work" "tcoil2586.gds")

cv_schematic = dbOpenCellViewByType("tcoil" "tcoil_master" "schematic")
CCSchangeParam( "tcoil" "tcoil_master" "schematic" "tcoil3_mmw" "pneo" "60" )
CCSchangeParam( "tcoil" "tcoil_master" "schematic" "tcoil3_mmw" "ctapLocation" "bot" )
CCSchangeParam( "tcoil" "tcoil_master" "schematic" "tcoil3_mmw" "od" "34u" )
CCSchangeParam( "tcoil" "tcoil_master" "schematic" "tcoil3_mmw" "w" "4.2u" )
CCSchangeParam( "tcoil" "tcoil_master" "schematic" "tcoil3_mmw" "neo" "8" )
CCSchangeParam( "tcoil" "tcoil_master" "schematic" "tcoil3_mmw" "nei" "5" )
lxGenFromSource( cv_schematic )
cv_layout = dbOpenCellViewByType("tcoil" "tcoil_master" "layout")
MovePinsToInstances( cv_schematic cv_layout )
StreamOutGDS("tcoil" "tcoil_master" "layout" "/autofs/fs1.ece/fs1.eecg.tcc/lizongh2/gf22x-1020b/EMX_work/tcoil_tcoil2587.work" "tcoil2587.gds")

cv_schematic = dbOpenCellViewByType("tcoil" "tcoil_master" "schematic")
CCSchangeParam( "tcoil" "tcoil_master" "schematic" "tcoil3_mmw" "pneo" "60" )
CCSchangeParam( "tcoil" "tcoil_master" "schematic" "tcoil3_mmw" "ctapLocation" "bot" )
CCSchangeParam( "tcoil" "tcoil_master" "schematic" "tcoil3_mmw" "od" "34u" )
CCSchangeParam( "tcoil" "tcoil_master" "schematic" "tcoil3_mmw" "w" "4.2u" )
CCSchangeParam( "tcoil" "tcoil_master" "schematic" "tcoil3_mmw" "neo" "10" )
CCSchangeParam( "tcoil" "tcoil_master" "schematic" "tcoil3_mmw" "nei" "5" )
lxGenFromSource( cv_schematic )
cv_layout = dbOpenCellViewByType("tcoil" "tcoil_master" "layout")
MovePinsToInstances( cv_schematic cv_layout )
StreamOutGDS("tcoil" "tcoil_master" "layout" "/autofs/fs1.ece/fs1.eecg.tcc/lizongh2/gf22x-1020b/EMX_work/tcoil_tcoil2588.work" "tcoil2588.gds")

cv_schematic = dbOpenCellViewByType("tcoil" "tcoil_master" "schematic")
CCSchangeParam( "tcoil" "tcoil_master" "schematic" "tcoil3_mmw" "pneo" "60" )
CCSchangeParam( "tcoil" "tcoil_master" "schematic" "tcoil3_mmw" "ctapLocation" "bot" )
CCSchangeParam( "tcoil" "tcoil_master" "schematic" "tcoil3_mmw" "od" "34u" )
CCSchangeParam( "tcoil" "tcoil_master" "schematic" "tcoil3_mmw" "w" "4.2u" )
CCSchangeParam( "tcoil" "tcoil_master" "schematic" "tcoil3_mmw" "neo" "12" )
CCSchangeParam( "tcoil" "tcoil_master" "schematic" "tcoil3_mmw" "nei" "5" )
lxGenFromSource( cv_schematic )
cv_layout = dbOpenCellViewByType("tcoil" "tcoil_master" "layout")
MovePinsToInstances( cv_schematic cv_layout )
StreamOutGDS("tcoil" "tcoil_master" "layout" "/autofs/fs1.ece/fs1.eecg.tcc/lizongh2/gf22x-1020b/EMX_work/tcoil_tcoil2589.work" "tcoil2589.gds")

cv_schematic = dbOpenCellViewByType("tcoil" "tcoil_master" "schematic")
CCSchangeParam( "tcoil" "tcoil_master" "schematic" "tcoil3_mmw" "pneo" "60" )
CCSchangeParam( "tcoil" "tcoil_master" "schematic" "tcoil3_mmw" "ctapLocation" "bot" )
CCSchangeParam( "tcoil" "tcoil_master" "schematic" "tcoil3_mmw" "od" "34u" )
CCSchangeParam( "tcoil" "tcoil_master" "schematic" "tcoil3_mmw" "w" "4.2u" )
CCSchangeParam( "tcoil" "tcoil_master" "schematic" "tcoil3_mmw" "neo" "4" )
CCSchangeParam( "tcoil" "tcoil_master" "schematic" "tcoil3_mmw" "nei" "6" )
lxGenFromSource( cv_schematic )
cv_layout = dbOpenCellViewByType("tcoil" "tcoil_master" "layout")
MovePinsToInstances( cv_schematic cv_layout )
StreamOutGDS("tcoil" "tcoil_master" "layout" "/autofs/fs1.ece/fs1.eecg.tcc/lizongh2/gf22x-1020b/EMX_work/tcoil_tcoil2590.work" "tcoil2590.gds")

cv_schematic = dbOpenCellViewByType("tcoil" "tcoil_master" "schematic")
CCSchangeParam( "tcoil" "tcoil_master" "schematic" "tcoil3_mmw" "pneo" "60" )
CCSchangeParam( "tcoil" "tcoil_master" "schematic" "tcoil3_mmw" "ctapLocation" "bot" )
CCSchangeParam( "tcoil" "tcoil_master" "schematic" "tcoil3_mmw" "od" "34u" )
CCSchangeParam( "tcoil" "tcoil_master" "schematic" "tcoil3_mmw" "w" "4.2u" )
CCSchangeParam( "tcoil" "tcoil_master" "schematic" "tcoil3_mmw" "neo" "6" )
CCSchangeParam( "tcoil" "tcoil_master" "schematic" "tcoil3_mmw" "nei" "6" )
lxGenFromSource( cv_schematic )
cv_layout = dbOpenCellViewByType("tcoil" "tcoil_master" "layout")
MovePinsToInstances( cv_schematic cv_layout )
StreamOutGDS("tcoil" "tcoil_master" "layout" "/autofs/fs1.ece/fs1.eecg.tcc/lizongh2/gf22x-1020b/EMX_work/tcoil_tcoil2591.work" "tcoil2591.gds")

cv_schematic = dbOpenCellViewByType("tcoil" "tcoil_master" "schematic")
CCSchangeParam( "tcoil" "tcoil_master" "schematic" "tcoil3_mmw" "pneo" "60" )
CCSchangeParam( "tcoil" "tcoil_master" "schematic" "tcoil3_mmw" "ctapLocation" "bot" )
CCSchangeParam( "tcoil" "tcoil_master" "schematic" "tcoil3_mmw" "od" "34u" )
CCSchangeParam( "tcoil" "tcoil_master" "schematic" "tcoil3_mmw" "w" "4.2u" )
CCSchangeParam( "tcoil" "tcoil_master" "schematic" "tcoil3_mmw" "neo" "8" )
CCSchangeParam( "tcoil" "tcoil_master" "schematic" "tcoil3_mmw" "nei" "6" )
lxGenFromSource( cv_schematic )
cv_layout = dbOpenCellViewByType("tcoil" "tcoil_master" "layout")
MovePinsToInstances( cv_schematic cv_layout )
StreamOutGDS("tcoil" "tcoil_master" "layout" "/autofs/fs1.ece/fs1.eecg.tcc/lizongh2/gf22x-1020b/EMX_work/tcoil_tcoil2592.work" "tcoil2592.gds")

cv_schematic = dbOpenCellViewByType("tcoil" "tcoil_master" "schematic")
CCSchangeParam( "tcoil" "tcoil_master" "schematic" "tcoil3_mmw" "pneo" "60" )
CCSchangeParam( "tcoil" "tcoil_master" "schematic" "tcoil3_mmw" "ctapLocation" "bot" )
CCSchangeParam( "tcoil" "tcoil_master" "schematic" "tcoil3_mmw" "od" "34u" )
CCSchangeParam( "tcoil" "tcoil_master" "schematic" "tcoil3_mmw" "w" "4.2u" )
CCSchangeParam( "tcoil" "tcoil_master" "schematic" "tcoil3_mmw" "neo" "10" )
CCSchangeParam( "tcoil" "tcoil_master" "schematic" "tcoil3_mmw" "nei" "6" )
lxGenFromSource( cv_schematic )
cv_layout = dbOpenCellViewByType("tcoil" "tcoil_master" "layout")
MovePinsToInstances( cv_schematic cv_layout )
StreamOutGDS("tcoil" "tcoil_master" "layout" "/autofs/fs1.ece/fs1.eecg.tcc/lizongh2/gf22x-1020b/EMX_work/tcoil_tcoil2593.work" "tcoil2593.gds")

cv_schematic = dbOpenCellViewByType("tcoil" "tcoil_master" "schematic")
CCSchangeParam( "tcoil" "tcoil_master" "schematic" "tcoil3_mmw" "pneo" "60" )
CCSchangeParam( "tcoil" "tcoil_master" "schematic" "tcoil3_mmw" "ctapLocation" "bot" )
CCSchangeParam( "tcoil" "tcoil_master" "schematic" "tcoil3_mmw" "od" "34u" )
CCSchangeParam( "tcoil" "tcoil_master" "schematic" "tcoil3_mmw" "w" "4.2u" )
CCSchangeParam( "tcoil" "tcoil_master" "schematic" "tcoil3_mmw" "neo" "12" )
CCSchangeParam( "tcoil" "tcoil_master" "schematic" "tcoil3_mmw" "nei" "6" )
lxGenFromSource( cv_schematic )
cv_layout = dbOpenCellViewByType("tcoil" "tcoil_master" "layout")
MovePinsToInstances( cv_schematic cv_layout )
StreamOutGDS("tcoil" "tcoil_master" "layout" "/autofs/fs1.ece/fs1.eecg.tcc/lizongh2/gf22x-1020b/EMX_work/tcoil_tcoil2594.work" "tcoil2594.gds")

cv_schematic = dbOpenCellViewByType("tcoil" "tcoil_master" "schematic")
CCSchangeParam( "tcoil" "tcoil_master" "schematic" "tcoil3_mmw" "pneo" "60" )
CCSchangeParam( "tcoil" "tcoil_master" "schematic" "tcoil3_mmw" "ctapLocation" "bot" )
CCSchangeParam( "tcoil" "tcoil_master" "schematic" "tcoil3_mmw" "od" "36u" )
CCSchangeParam( "tcoil" "tcoil_master" "schematic" "tcoil3_mmw" "w" "2.4u" )
CCSchangeParam( "tcoil" "tcoil_master" "schematic" "tcoil3_mmw" "neo" "4" )
CCSchangeParam( "tcoil" "tcoil_master" "schematic" "tcoil3_mmw" "nei" "5" )
lxGenFromSource( cv_schematic )
cv_layout = dbOpenCellViewByType("tcoil" "tcoil_master" "layout")
MovePinsToInstances( cv_schematic cv_layout )
StreamOutGDS("tcoil" "tcoil_master" "layout" "/autofs/fs1.ece/fs1.eecg.tcc/lizongh2/gf22x-1020b/EMX_work/tcoil_tcoil2595.work" "tcoil2595.gds")

cv_schematic = dbOpenCellViewByType("tcoil" "tcoil_master" "schematic")
CCSchangeParam( "tcoil" "tcoil_master" "schematic" "tcoil3_mmw" "pneo" "60" )
CCSchangeParam( "tcoil" "tcoil_master" "schematic" "tcoil3_mmw" "ctapLocation" "bot" )
CCSchangeParam( "tcoil" "tcoil_master" "schematic" "tcoil3_mmw" "od" "36u" )
CCSchangeParam( "tcoil" "tcoil_master" "schematic" "tcoil3_mmw" "w" "2.4u" )
CCSchangeParam( "tcoil" "tcoil_master" "schematic" "tcoil3_mmw" "neo" "6" )
CCSchangeParam( "tcoil" "tcoil_master" "schematic" "tcoil3_mmw" "nei" "5" )
lxGenFromSource( cv_schematic )
cv_layout = dbOpenCellViewByType("tcoil" "tcoil_master" "layout")
MovePinsToInstances( cv_schematic cv_layout )
StreamOutGDS("tcoil" "tcoil_master" "layout" "/autofs/fs1.ece/fs1.eecg.tcc/lizongh2/gf22x-1020b/EMX_work/tcoil_tcoil2596.work" "tcoil2596.gds")

cv_schematic = dbOpenCellViewByType("tcoil" "tcoil_master" "schematic")
CCSchangeParam( "tcoil" "tcoil_master" "schematic" "tcoil3_mmw" "pneo" "60" )
CCSchangeParam( "tcoil" "tcoil_master" "schematic" "tcoil3_mmw" "ctapLocation" "bot" )
CCSchangeParam( "tcoil" "tcoil_master" "schematic" "tcoil3_mmw" "od" "36u" )
CCSchangeParam( "tcoil" "tcoil_master" "schematic" "tcoil3_mmw" "w" "2.4u" )
CCSchangeParam( "tcoil" "tcoil_master" "schematic" "tcoil3_mmw" "neo" "8" )
CCSchangeParam( "tcoil" "tcoil_master" "schematic" "tcoil3_mmw" "nei" "5" )
lxGenFromSource( cv_schematic )
cv_layout = dbOpenCellViewByType("tcoil" "tcoil_master" "layout")
MovePinsToInstances( cv_schematic cv_layout )
StreamOutGDS("tcoil" "tcoil_master" "layout" "/autofs/fs1.ece/fs1.eecg.tcc/lizongh2/gf22x-1020b/EMX_work/tcoil_tcoil2597.work" "tcoil2597.gds")

cv_schematic = dbOpenCellViewByType("tcoil" "tcoil_master" "schematic")
CCSchangeParam( "tcoil" "tcoil_master" "schematic" "tcoil3_mmw" "pneo" "60" )
CCSchangeParam( "tcoil" "tcoil_master" "schematic" "tcoil3_mmw" "ctapLocation" "bot" )
CCSchangeParam( "tcoil" "tcoil_master" "schematic" "tcoil3_mmw" "od" "36u" )
CCSchangeParam( "tcoil" "tcoil_master" "schematic" "tcoil3_mmw" "w" "2.4u" )
CCSchangeParam( "tcoil" "tcoil_master" "schematic" "tcoil3_mmw" "neo" "10" )
CCSchangeParam( "tcoil" "tcoil_master" "schematic" "tcoil3_mmw" "nei" "5" )
lxGenFromSource( cv_schematic )
cv_layout = dbOpenCellViewByType("tcoil" "tcoil_master" "layout")
MovePinsToInstances( cv_schematic cv_layout )
StreamOutGDS("tcoil" "tcoil_master" "layout" "/autofs/fs1.ece/fs1.eecg.tcc/lizongh2/gf22x-1020b/EMX_work/tcoil_tcoil2598.work" "tcoil2598.gds")

cv_schematic = dbOpenCellViewByType("tcoil" "tcoil_master" "schematic")
CCSchangeParam( "tcoil" "tcoil_master" "schematic" "tcoil3_mmw" "pneo" "60" )
CCSchangeParam( "tcoil" "tcoil_master" "schematic" "tcoil3_mmw" "ctapLocation" "bot" )
CCSchangeParam( "tcoil" "tcoil_master" "schematic" "tcoil3_mmw" "od" "36u" )
CCSchangeParam( "tcoil" "tcoil_master" "schematic" "tcoil3_mmw" "w" "2.4u" )
CCSchangeParam( "tcoil" "tcoil_master" "schematic" "tcoil3_mmw" "neo" "12" )
CCSchangeParam( "tcoil" "tcoil_master" "schematic" "tcoil3_mmw" "nei" "5" )
lxGenFromSource( cv_schematic )
cv_layout = dbOpenCellViewByType("tcoil" "tcoil_master" "layout")
MovePinsToInstances( cv_schematic cv_layout )
StreamOutGDS("tcoil" "tcoil_master" "layout" "/autofs/fs1.ece/fs1.eecg.tcc/lizongh2/gf22x-1020b/EMX_work/tcoil_tcoil2599.work" "tcoil2599.gds")

cv_schematic = dbOpenCellViewByType("tcoil" "tcoil_master" "schematic")
CCSchangeParam( "tcoil" "tcoil_master" "schematic" "tcoil3_mmw" "pneo" "60" )
CCSchangeParam( "tcoil" "tcoil_master" "schematic" "tcoil3_mmw" "ctapLocation" "bot" )
CCSchangeParam( "tcoil" "tcoil_master" "schematic" "tcoil3_mmw" "od" "36u" )
CCSchangeParam( "tcoil" "tcoil_master" "schematic" "tcoil3_mmw" "w" "4.2u" )
CCSchangeParam( "tcoil" "tcoil_master" "schematic" "tcoil3_mmw" "neo" "4" )
CCSchangeParam( "tcoil" "tcoil_master" "schematic" "tcoil3_mmw" "nei" "5" )
lxGenFromSource( cv_schematic )
cv_layout = dbOpenCellViewByType("tcoil" "tcoil_master" "layout")
MovePinsToInstances( cv_schematic cv_layout )
StreamOutGDS("tcoil" "tcoil_master" "layout" "/autofs/fs1.ece/fs1.eecg.tcc/lizongh2/gf22x-1020b/EMX_work/tcoil_tcoil2600.work" "tcoil2600.gds")

cv_schematic = dbOpenCellViewByType("tcoil" "tcoil_master" "schematic")
CCSchangeParam( "tcoil" "tcoil_master" "schematic" "tcoil3_mmw" "pneo" "60" )
CCSchangeParam( "tcoil" "tcoil_master" "schematic" "tcoil3_mmw" "ctapLocation" "bot" )
CCSchangeParam( "tcoil" "tcoil_master" "schematic" "tcoil3_mmw" "od" "36u" )
CCSchangeParam( "tcoil" "tcoil_master" "schematic" "tcoil3_mmw" "w" "4.2u" )
CCSchangeParam( "tcoil" "tcoil_master" "schematic" "tcoil3_mmw" "neo" "6" )
CCSchangeParam( "tcoil" "tcoil_master" "schematic" "tcoil3_mmw" "nei" "5" )
lxGenFromSource( cv_schematic )
cv_layout = dbOpenCellViewByType("tcoil" "tcoil_master" "layout")
MovePinsToInstances( cv_schematic cv_layout )
StreamOutGDS("tcoil" "tcoil_master" "layout" "/autofs/fs1.ece/fs1.eecg.tcc/lizongh2/gf22x-1020b/EMX_work/tcoil_tcoil2601.work" "tcoil2601.gds")

cv_schematic = dbOpenCellViewByType("tcoil" "tcoil_master" "schematic")
CCSchangeParam( "tcoil" "tcoil_master" "schematic" "tcoil3_mmw" "pneo" "60" )
CCSchangeParam( "tcoil" "tcoil_master" "schematic" "tcoil3_mmw" "ctapLocation" "bot" )
CCSchangeParam( "tcoil" "tcoil_master" "schematic" "tcoil3_mmw" "od" "36u" )
CCSchangeParam( "tcoil" "tcoil_master" "schematic" "tcoil3_mmw" "w" "4.2u" )
CCSchangeParam( "tcoil" "tcoil_master" "schematic" "tcoil3_mmw" "neo" "8" )
CCSchangeParam( "tcoil" "tcoil_master" "schematic" "tcoil3_mmw" "nei" "5" )
lxGenFromSource( cv_schematic )
cv_layout = dbOpenCellViewByType("tcoil" "tcoil_master" "layout")
MovePinsToInstances( cv_schematic cv_layout )
StreamOutGDS("tcoil" "tcoil_master" "layout" "/autofs/fs1.ece/fs1.eecg.tcc/lizongh2/gf22x-1020b/EMX_work/tcoil_tcoil2602.work" "tcoil2602.gds")

cv_schematic = dbOpenCellViewByType("tcoil" "tcoil_master" "schematic")
CCSchangeParam( "tcoil" "tcoil_master" "schematic" "tcoil3_mmw" "pneo" "60" )
CCSchangeParam( "tcoil" "tcoil_master" "schematic" "tcoil3_mmw" "ctapLocation" "bot" )
CCSchangeParam( "tcoil" "tcoil_master" "schematic" "tcoil3_mmw" "od" "36u" )
CCSchangeParam( "tcoil" "tcoil_master" "schematic" "tcoil3_mmw" "w" "4.2u" )
CCSchangeParam( "tcoil" "tcoil_master" "schematic" "tcoil3_mmw" "neo" "10" )
CCSchangeParam( "tcoil" "tcoil_master" "schematic" "tcoil3_mmw" "nei" "5" )
lxGenFromSource( cv_schematic )
cv_layout = dbOpenCellViewByType("tcoil" "tcoil_master" "layout")
MovePinsToInstances( cv_schematic cv_layout )
StreamOutGDS("tcoil" "tcoil_master" "layout" "/autofs/fs1.ece/fs1.eecg.tcc/lizongh2/gf22x-1020b/EMX_work/tcoil_tcoil2603.work" "tcoil2603.gds")

cv_schematic = dbOpenCellViewByType("tcoil" "tcoil_master" "schematic")
CCSchangeParam( "tcoil" "tcoil_master" "schematic" "tcoil3_mmw" "pneo" "60" )
CCSchangeParam( "tcoil" "tcoil_master" "schematic" "tcoil3_mmw" "ctapLocation" "bot" )
CCSchangeParam( "tcoil" "tcoil_master" "schematic" "tcoil3_mmw" "od" "36u" )
CCSchangeParam( "tcoil" "tcoil_master" "schematic" "tcoil3_mmw" "w" "4.2u" )
CCSchangeParam( "tcoil" "tcoil_master" "schematic" "tcoil3_mmw" "neo" "12" )
CCSchangeParam( "tcoil" "tcoil_master" "schematic" "tcoil3_mmw" "nei" "5" )
lxGenFromSource( cv_schematic )
cv_layout = dbOpenCellViewByType("tcoil" "tcoil_master" "layout")
MovePinsToInstances( cv_schematic cv_layout )
StreamOutGDS("tcoil" "tcoil_master" "layout" "/autofs/fs1.ece/fs1.eecg.tcc/lizongh2/gf22x-1020b/EMX_work/tcoil_tcoil2604.work" "tcoil2604.gds")

cv_schematic = dbOpenCellViewByType("tcoil" "tcoil_master" "schematic")
CCSchangeParam( "tcoil" "tcoil_master" "schematic" "tcoil3_mmw" "pneo" "60" )
CCSchangeParam( "tcoil" "tcoil_master" "schematic" "tcoil3_mmw" "ctapLocation" "bot" )
CCSchangeParam( "tcoil" "tcoil_master" "schematic" "tcoil3_mmw" "od" "36u" )
CCSchangeParam( "tcoil" "tcoil_master" "schematic" "tcoil3_mmw" "w" "4.2u" )
CCSchangeParam( "tcoil" "tcoil_master" "schematic" "tcoil3_mmw" "neo" "4" )
CCSchangeParam( "tcoil" "tcoil_master" "schematic" "tcoil3_mmw" "nei" "6" )
lxGenFromSource( cv_schematic )
cv_layout = dbOpenCellViewByType("tcoil" "tcoil_master" "layout")
MovePinsToInstances( cv_schematic cv_layout )
StreamOutGDS("tcoil" "tcoil_master" "layout" "/autofs/fs1.ece/fs1.eecg.tcc/lizongh2/gf22x-1020b/EMX_work/tcoil_tcoil2605.work" "tcoil2605.gds")

cv_schematic = dbOpenCellViewByType("tcoil" "tcoil_master" "schematic")
CCSchangeParam( "tcoil" "tcoil_master" "schematic" "tcoil3_mmw" "pneo" "60" )
CCSchangeParam( "tcoil" "tcoil_master" "schematic" "tcoil3_mmw" "ctapLocation" "bot" )
CCSchangeParam( "tcoil" "tcoil_master" "schematic" "tcoil3_mmw" "od" "36u" )
CCSchangeParam( "tcoil" "tcoil_master" "schematic" "tcoil3_mmw" "w" "4.2u" )
CCSchangeParam( "tcoil" "tcoil_master" "schematic" "tcoil3_mmw" "neo" "6" )
CCSchangeParam( "tcoil" "tcoil_master" "schematic" "tcoil3_mmw" "nei" "6" )
lxGenFromSource( cv_schematic )
cv_layout = dbOpenCellViewByType("tcoil" "tcoil_master" "layout")
MovePinsToInstances( cv_schematic cv_layout )
StreamOutGDS("tcoil" "tcoil_master" "layout" "/autofs/fs1.ece/fs1.eecg.tcc/lizongh2/gf22x-1020b/EMX_work/tcoil_tcoil2606.work" "tcoil2606.gds")

cv_schematic = dbOpenCellViewByType("tcoil" "tcoil_master" "schematic")
CCSchangeParam( "tcoil" "tcoil_master" "schematic" "tcoil3_mmw" "pneo" "60" )
CCSchangeParam( "tcoil" "tcoil_master" "schematic" "tcoil3_mmw" "ctapLocation" "bot" )
CCSchangeParam( "tcoil" "tcoil_master" "schematic" "tcoil3_mmw" "od" "36u" )
CCSchangeParam( "tcoil" "tcoil_master" "schematic" "tcoil3_mmw" "w" "4.2u" )
CCSchangeParam( "tcoil" "tcoil_master" "schematic" "tcoil3_mmw" "neo" "8" )
CCSchangeParam( "tcoil" "tcoil_master" "schematic" "tcoil3_mmw" "nei" "6" )
lxGenFromSource( cv_schematic )
cv_layout = dbOpenCellViewByType("tcoil" "tcoil_master" "layout")
MovePinsToInstances( cv_schematic cv_layout )
StreamOutGDS("tcoil" "tcoil_master" "layout" "/autofs/fs1.ece/fs1.eecg.tcc/lizongh2/gf22x-1020b/EMX_work/tcoil_tcoil2607.work" "tcoil2607.gds")

cv_schematic = dbOpenCellViewByType("tcoil" "tcoil_master" "schematic")
CCSchangeParam( "tcoil" "tcoil_master" "schematic" "tcoil3_mmw" "pneo" "60" )
CCSchangeParam( "tcoil" "tcoil_master" "schematic" "tcoil3_mmw" "ctapLocation" "bot" )
CCSchangeParam( "tcoil" "tcoil_master" "schematic" "tcoil3_mmw" "od" "36u" )
CCSchangeParam( "tcoil" "tcoil_master" "schematic" "tcoil3_mmw" "w" "4.2u" )
CCSchangeParam( "tcoil" "tcoil_master" "schematic" "tcoil3_mmw" "neo" "10" )
CCSchangeParam( "tcoil" "tcoil_master" "schematic" "tcoil3_mmw" "nei" "6" )
lxGenFromSource( cv_schematic )
cv_layout = dbOpenCellViewByType("tcoil" "tcoil_master" "layout")
MovePinsToInstances( cv_schematic cv_layout )
StreamOutGDS("tcoil" "tcoil_master" "layout" "/autofs/fs1.ece/fs1.eecg.tcc/lizongh2/gf22x-1020b/EMX_work/tcoil_tcoil2608.work" "tcoil2608.gds")

cv_schematic = dbOpenCellViewByType("tcoil" "tcoil_master" "schematic")
CCSchangeParam( "tcoil" "tcoil_master" "schematic" "tcoil3_mmw" "pneo" "60" )
CCSchangeParam( "tcoil" "tcoil_master" "schematic" "tcoil3_mmw" "ctapLocation" "bot" )
CCSchangeParam( "tcoil" "tcoil_master" "schematic" "tcoil3_mmw" "od" "36u" )
CCSchangeParam( "tcoil" "tcoil_master" "schematic" "tcoil3_mmw" "w" "4.2u" )
CCSchangeParam( "tcoil" "tcoil_master" "schematic" "tcoil3_mmw" "neo" "12" )
CCSchangeParam( "tcoil" "tcoil_master" "schematic" "tcoil3_mmw" "nei" "6" )
lxGenFromSource( cv_schematic )
cv_layout = dbOpenCellViewByType("tcoil" "tcoil_master" "layout")
MovePinsToInstances( cv_schematic cv_layout )
StreamOutGDS("tcoil" "tcoil_master" "layout" "/autofs/fs1.ece/fs1.eecg.tcc/lizongh2/gf22x-1020b/EMX_work/tcoil_tcoil2609.work" "tcoil2609.gds")

cv_schematic = dbOpenCellViewByType("tcoil" "tcoil_master" "schematic")
CCSchangeParam( "tcoil" "tcoil_master" "schematic" "tcoil3_mmw" "pneo" "60" )
CCSchangeParam( "tcoil" "tcoil_master" "schematic" "tcoil3_mmw" "ctapLocation" "bot" )
CCSchangeParam( "tcoil" "tcoil_master" "schematic" "tcoil3_mmw" "od" "38u" )
CCSchangeParam( "tcoil" "tcoil_master" "schematic" "tcoil3_mmw" "w" "2.4u" )
CCSchangeParam( "tcoil" "tcoil_master" "schematic" "tcoil3_mmw" "neo" "4" )
CCSchangeParam( "tcoil" "tcoil_master" "schematic" "tcoil3_mmw" "nei" "5" )
lxGenFromSource( cv_schematic )
cv_layout = dbOpenCellViewByType("tcoil" "tcoil_master" "layout")
MovePinsToInstances( cv_schematic cv_layout )
StreamOutGDS("tcoil" "tcoil_master" "layout" "/autofs/fs1.ece/fs1.eecg.tcc/lizongh2/gf22x-1020b/EMX_work/tcoil_tcoil2610.work" "tcoil2610.gds")

cv_schematic = dbOpenCellViewByType("tcoil" "tcoil_master" "schematic")
CCSchangeParam( "tcoil" "tcoil_master" "schematic" "tcoil3_mmw" "pneo" "60" )
CCSchangeParam( "tcoil" "tcoil_master" "schematic" "tcoil3_mmw" "ctapLocation" "bot" )
CCSchangeParam( "tcoil" "tcoil_master" "schematic" "tcoil3_mmw" "od" "38u" )
CCSchangeParam( "tcoil" "tcoil_master" "schematic" "tcoil3_mmw" "w" "2.4u" )
CCSchangeParam( "tcoil" "tcoil_master" "schematic" "tcoil3_mmw" "neo" "6" )
CCSchangeParam( "tcoil" "tcoil_master" "schematic" "tcoil3_mmw" "nei" "5" )
lxGenFromSource( cv_schematic )
cv_layout = dbOpenCellViewByType("tcoil" "tcoil_master" "layout")
MovePinsToInstances( cv_schematic cv_layout )
StreamOutGDS("tcoil" "tcoil_master" "layout" "/autofs/fs1.ece/fs1.eecg.tcc/lizongh2/gf22x-1020b/EMX_work/tcoil_tcoil2611.work" "tcoil2611.gds")

cv_schematic = dbOpenCellViewByType("tcoil" "tcoil_master" "schematic")
CCSchangeParam( "tcoil" "tcoil_master" "schematic" "tcoil3_mmw" "pneo" "60" )
CCSchangeParam( "tcoil" "tcoil_master" "schematic" "tcoil3_mmw" "ctapLocation" "bot" )
CCSchangeParam( "tcoil" "tcoil_master" "schematic" "tcoil3_mmw" "od" "38u" )
CCSchangeParam( "tcoil" "tcoil_master" "schematic" "tcoil3_mmw" "w" "2.4u" )
CCSchangeParam( "tcoil" "tcoil_master" "schematic" "tcoil3_mmw" "neo" "8" )
CCSchangeParam( "tcoil" "tcoil_master" "schematic" "tcoil3_mmw" "nei" "5" )
lxGenFromSource( cv_schematic )
cv_layout = dbOpenCellViewByType("tcoil" "tcoil_master" "layout")
MovePinsToInstances( cv_schematic cv_layout )
StreamOutGDS("tcoil" "tcoil_master" "layout" "/autofs/fs1.ece/fs1.eecg.tcc/lizongh2/gf22x-1020b/EMX_work/tcoil_tcoil2612.work" "tcoil2612.gds")

cv_schematic = dbOpenCellViewByType("tcoil" "tcoil_master" "schematic")
CCSchangeParam( "tcoil" "tcoil_master" "schematic" "tcoil3_mmw" "pneo" "60" )
CCSchangeParam( "tcoil" "tcoil_master" "schematic" "tcoil3_mmw" "ctapLocation" "bot" )
CCSchangeParam( "tcoil" "tcoil_master" "schematic" "tcoil3_mmw" "od" "38u" )
CCSchangeParam( "tcoil" "tcoil_master" "schematic" "tcoil3_mmw" "w" "2.4u" )
CCSchangeParam( "tcoil" "tcoil_master" "schematic" "tcoil3_mmw" "neo" "10" )
CCSchangeParam( "tcoil" "tcoil_master" "schematic" "tcoil3_mmw" "nei" "5" )
lxGenFromSource( cv_schematic )
cv_layout = dbOpenCellViewByType("tcoil" "tcoil_master" "layout")
MovePinsToInstances( cv_schematic cv_layout )
StreamOutGDS("tcoil" "tcoil_master" "layout" "/autofs/fs1.ece/fs1.eecg.tcc/lizongh2/gf22x-1020b/EMX_work/tcoil_tcoil2613.work" "tcoil2613.gds")

cv_schematic = dbOpenCellViewByType("tcoil" "tcoil_master" "schematic")
CCSchangeParam( "tcoil" "tcoil_master" "schematic" "tcoil3_mmw" "pneo" "60" )
CCSchangeParam( "tcoil" "tcoil_master" "schematic" "tcoil3_mmw" "ctapLocation" "bot" )
CCSchangeParam( "tcoil" "tcoil_master" "schematic" "tcoil3_mmw" "od" "38u" )
CCSchangeParam( "tcoil" "tcoil_master" "schematic" "tcoil3_mmw" "w" "2.4u" )
CCSchangeParam( "tcoil" "tcoil_master" "schematic" "tcoil3_mmw" "neo" "12" )
CCSchangeParam( "tcoil" "tcoil_master" "schematic" "tcoil3_mmw" "nei" "5" )
lxGenFromSource( cv_schematic )
cv_layout = dbOpenCellViewByType("tcoil" "tcoil_master" "layout")
MovePinsToInstances( cv_schematic cv_layout )
StreamOutGDS("tcoil" "tcoil_master" "layout" "/autofs/fs1.ece/fs1.eecg.tcc/lizongh2/gf22x-1020b/EMX_work/tcoil_tcoil2614.work" "tcoil2614.gds")

cv_schematic = dbOpenCellViewByType("tcoil" "tcoil_master" "schematic")
CCSchangeParam( "tcoil" "tcoil_master" "schematic" "tcoil3_mmw" "pneo" "60" )
CCSchangeParam( "tcoil" "tcoil_master" "schematic" "tcoil3_mmw" "ctapLocation" "bot" )
CCSchangeParam( "tcoil" "tcoil_master" "schematic" "tcoil3_mmw" "od" "38u" )
CCSchangeParam( "tcoil" "tcoil_master" "schematic" "tcoil3_mmw" "w" "4.2u" )
CCSchangeParam( "tcoil" "tcoil_master" "schematic" "tcoil3_mmw" "neo" "4" )
CCSchangeParam( "tcoil" "tcoil_master" "schematic" "tcoil3_mmw" "nei" "5" )
lxGenFromSource( cv_schematic )
cv_layout = dbOpenCellViewByType("tcoil" "tcoil_master" "layout")
MovePinsToInstances( cv_schematic cv_layout )
StreamOutGDS("tcoil" "tcoil_master" "layout" "/autofs/fs1.ece/fs1.eecg.tcc/lizongh2/gf22x-1020b/EMX_work/tcoil_tcoil2615.work" "tcoil2615.gds")

cv_schematic = dbOpenCellViewByType("tcoil" "tcoil_master" "schematic")
CCSchangeParam( "tcoil" "tcoil_master" "schematic" "tcoil3_mmw" "pneo" "60" )
CCSchangeParam( "tcoil" "tcoil_master" "schematic" "tcoil3_mmw" "ctapLocation" "bot" )
CCSchangeParam( "tcoil" "tcoil_master" "schematic" "tcoil3_mmw" "od" "38u" )
CCSchangeParam( "tcoil" "tcoil_master" "schematic" "tcoil3_mmw" "w" "4.2u" )
CCSchangeParam( "tcoil" "tcoil_master" "schematic" "tcoil3_mmw" "neo" "6" )
CCSchangeParam( "tcoil" "tcoil_master" "schematic" "tcoil3_mmw" "nei" "5" )
lxGenFromSource( cv_schematic )
cv_layout = dbOpenCellViewByType("tcoil" "tcoil_master" "layout")
MovePinsToInstances( cv_schematic cv_layout )
StreamOutGDS("tcoil" "tcoil_master" "layout" "/autofs/fs1.ece/fs1.eecg.tcc/lizongh2/gf22x-1020b/EMX_work/tcoil_tcoil2616.work" "tcoil2616.gds")

cv_schematic = dbOpenCellViewByType("tcoil" "tcoil_master" "schematic")
CCSchangeParam( "tcoil" "tcoil_master" "schematic" "tcoil3_mmw" "pneo" "60" )
CCSchangeParam( "tcoil" "tcoil_master" "schematic" "tcoil3_mmw" "ctapLocation" "bot" )
CCSchangeParam( "tcoil" "tcoil_master" "schematic" "tcoil3_mmw" "od" "38u" )
CCSchangeParam( "tcoil" "tcoil_master" "schematic" "tcoil3_mmw" "w" "4.2u" )
CCSchangeParam( "tcoil" "tcoil_master" "schematic" "tcoil3_mmw" "neo" "8" )
CCSchangeParam( "tcoil" "tcoil_master" "schematic" "tcoil3_mmw" "nei" "5" )
lxGenFromSource( cv_schematic )
cv_layout = dbOpenCellViewByType("tcoil" "tcoil_master" "layout")
MovePinsToInstances( cv_schematic cv_layout )
StreamOutGDS("tcoil" "tcoil_master" "layout" "/autofs/fs1.ece/fs1.eecg.tcc/lizongh2/gf22x-1020b/EMX_work/tcoil_tcoil2617.work" "tcoil2617.gds")

cv_schematic = dbOpenCellViewByType("tcoil" "tcoil_master" "schematic")
CCSchangeParam( "tcoil" "tcoil_master" "schematic" "tcoil3_mmw" "pneo" "60" )
CCSchangeParam( "tcoil" "tcoil_master" "schematic" "tcoil3_mmw" "ctapLocation" "bot" )
CCSchangeParam( "tcoil" "tcoil_master" "schematic" "tcoil3_mmw" "od" "38u" )
CCSchangeParam( "tcoil" "tcoil_master" "schematic" "tcoil3_mmw" "w" "4.2u" )
CCSchangeParam( "tcoil" "tcoil_master" "schematic" "tcoil3_mmw" "neo" "10" )
CCSchangeParam( "tcoil" "tcoil_master" "schematic" "tcoil3_mmw" "nei" "5" )
lxGenFromSource( cv_schematic )
cv_layout = dbOpenCellViewByType("tcoil" "tcoil_master" "layout")
MovePinsToInstances( cv_schematic cv_layout )
StreamOutGDS("tcoil" "tcoil_master" "layout" "/autofs/fs1.ece/fs1.eecg.tcc/lizongh2/gf22x-1020b/EMX_work/tcoil_tcoil2618.work" "tcoil2618.gds")

cv_schematic = dbOpenCellViewByType("tcoil" "tcoil_master" "schematic")
CCSchangeParam( "tcoil" "tcoil_master" "schematic" "tcoil3_mmw" "pneo" "60" )
CCSchangeParam( "tcoil" "tcoil_master" "schematic" "tcoil3_mmw" "ctapLocation" "bot" )
CCSchangeParam( "tcoil" "tcoil_master" "schematic" "tcoil3_mmw" "od" "38u" )
CCSchangeParam( "tcoil" "tcoil_master" "schematic" "tcoil3_mmw" "w" "4.2u" )
CCSchangeParam( "tcoil" "tcoil_master" "schematic" "tcoil3_mmw" "neo" "12" )
CCSchangeParam( "tcoil" "tcoil_master" "schematic" "tcoil3_mmw" "nei" "5" )
lxGenFromSource( cv_schematic )
cv_layout = dbOpenCellViewByType("tcoil" "tcoil_master" "layout")
MovePinsToInstances( cv_schematic cv_layout )
StreamOutGDS("tcoil" "tcoil_master" "layout" "/autofs/fs1.ece/fs1.eecg.tcc/lizongh2/gf22x-1020b/EMX_work/tcoil_tcoil2619.work" "tcoil2619.gds")

cv_schematic = dbOpenCellViewByType("tcoil" "tcoil_master" "schematic")
CCSchangeParam( "tcoil" "tcoil_master" "schematic" "tcoil3_mmw" "pneo" "60" )
CCSchangeParam( "tcoil" "tcoil_master" "schematic" "tcoil3_mmw" "ctapLocation" "bot" )
CCSchangeParam( "tcoil" "tcoil_master" "schematic" "tcoil3_mmw" "od" "40u" )
CCSchangeParam( "tcoil" "tcoil_master" "schematic" "tcoil3_mmw" "w" "2.4u" )
CCSchangeParam( "tcoil" "tcoil_master" "schematic" "tcoil3_mmw" "neo" "4" )
CCSchangeParam( "tcoil" "tcoil_master" "schematic" "tcoil3_mmw" "nei" "5" )
lxGenFromSource( cv_schematic )
cv_layout = dbOpenCellViewByType("tcoil" "tcoil_master" "layout")
MovePinsToInstances( cv_schematic cv_layout )
StreamOutGDS("tcoil" "tcoil_master" "layout" "/autofs/fs1.ece/fs1.eecg.tcc/lizongh2/gf22x-1020b/EMX_work/tcoil_tcoil2620.work" "tcoil2620.gds")

cv_schematic = dbOpenCellViewByType("tcoil" "tcoil_master" "schematic")
CCSchangeParam( "tcoil" "tcoil_master" "schematic" "tcoil3_mmw" "pneo" "60" )
CCSchangeParam( "tcoil" "tcoil_master" "schematic" "tcoil3_mmw" "ctapLocation" "bot" )
CCSchangeParam( "tcoil" "tcoil_master" "schematic" "tcoil3_mmw" "od" "40u" )
CCSchangeParam( "tcoil" "tcoil_master" "schematic" "tcoil3_mmw" "w" "2.4u" )
CCSchangeParam( "tcoil" "tcoil_master" "schematic" "tcoil3_mmw" "neo" "6" )
CCSchangeParam( "tcoil" "tcoil_master" "schematic" "tcoil3_mmw" "nei" "5" )
lxGenFromSource( cv_schematic )
cv_layout = dbOpenCellViewByType("tcoil" "tcoil_master" "layout")
MovePinsToInstances( cv_schematic cv_layout )
StreamOutGDS("tcoil" "tcoil_master" "layout" "/autofs/fs1.ece/fs1.eecg.tcc/lizongh2/gf22x-1020b/EMX_work/tcoil_tcoil2621.work" "tcoil2621.gds")

cv_schematic = dbOpenCellViewByType("tcoil" "tcoil_master" "schematic")
CCSchangeParam( "tcoil" "tcoil_master" "schematic" "tcoil3_mmw" "pneo" "60" )
CCSchangeParam( "tcoil" "tcoil_master" "schematic" "tcoil3_mmw" "ctapLocation" "bot" )
CCSchangeParam( "tcoil" "tcoil_master" "schematic" "tcoil3_mmw" "od" "40u" )
CCSchangeParam( "tcoil" "tcoil_master" "schematic" "tcoil3_mmw" "w" "2.4u" )
CCSchangeParam( "tcoil" "tcoil_master" "schematic" "tcoil3_mmw" "neo" "8" )
CCSchangeParam( "tcoil" "tcoil_master" "schematic" "tcoil3_mmw" "nei" "5" )
lxGenFromSource( cv_schematic )
cv_layout = dbOpenCellViewByType("tcoil" "tcoil_master" "layout")
MovePinsToInstances( cv_schematic cv_layout )
StreamOutGDS("tcoil" "tcoil_master" "layout" "/autofs/fs1.ece/fs1.eecg.tcc/lizongh2/gf22x-1020b/EMX_work/tcoil_tcoil2622.work" "tcoil2622.gds")

cv_schematic = dbOpenCellViewByType("tcoil" "tcoil_master" "schematic")
CCSchangeParam( "tcoil" "tcoil_master" "schematic" "tcoil3_mmw" "pneo" "60" )
CCSchangeParam( "tcoil" "tcoil_master" "schematic" "tcoil3_mmw" "ctapLocation" "bot" )
CCSchangeParam( "tcoil" "tcoil_master" "schematic" "tcoil3_mmw" "od" "40u" )
CCSchangeParam( "tcoil" "tcoil_master" "schematic" "tcoil3_mmw" "w" "2.4u" )
CCSchangeParam( "tcoil" "tcoil_master" "schematic" "tcoil3_mmw" "neo" "10" )
CCSchangeParam( "tcoil" "tcoil_master" "schematic" "tcoil3_mmw" "nei" "5" )
lxGenFromSource( cv_schematic )
cv_layout = dbOpenCellViewByType("tcoil" "tcoil_master" "layout")
MovePinsToInstances( cv_schematic cv_layout )
StreamOutGDS("tcoil" "tcoil_master" "layout" "/autofs/fs1.ece/fs1.eecg.tcc/lizongh2/gf22x-1020b/EMX_work/tcoil_tcoil2623.work" "tcoil2623.gds")

cv_schematic = dbOpenCellViewByType("tcoil" "tcoil_master" "schematic")
CCSchangeParam( "tcoil" "tcoil_master" "schematic" "tcoil3_mmw" "pneo" "60" )
CCSchangeParam( "tcoil" "tcoil_master" "schematic" "tcoil3_mmw" "ctapLocation" "bot" )
CCSchangeParam( "tcoil" "tcoil_master" "schematic" "tcoil3_mmw" "od" "40u" )
CCSchangeParam( "tcoil" "tcoil_master" "schematic" "tcoil3_mmw" "w" "2.4u" )
CCSchangeParam( "tcoil" "tcoil_master" "schematic" "tcoil3_mmw" "neo" "12" )
CCSchangeParam( "tcoil" "tcoil_master" "schematic" "tcoil3_mmw" "nei" "5" )
lxGenFromSource( cv_schematic )
cv_layout = dbOpenCellViewByType("tcoil" "tcoil_master" "layout")
MovePinsToInstances( cv_schematic cv_layout )
StreamOutGDS("tcoil" "tcoil_master" "layout" "/autofs/fs1.ece/fs1.eecg.tcc/lizongh2/gf22x-1020b/EMX_work/tcoil_tcoil2624.work" "tcoil2624.gds")

cv_schematic = dbOpenCellViewByType("tcoil" "tcoil_master" "schematic")
CCSchangeParam( "tcoil" "tcoil_master" "schematic" "tcoil3_mmw" "pneo" "60" )
CCSchangeParam( "tcoil" "tcoil_master" "schematic" "tcoil3_mmw" "ctapLocation" "bot" )
CCSchangeParam( "tcoil" "tcoil_master" "schematic" "tcoil3_mmw" "od" "40u" )
CCSchangeParam( "tcoil" "tcoil_master" "schematic" "tcoil3_mmw" "w" "4.2u" )
CCSchangeParam( "tcoil" "tcoil_master" "schematic" "tcoil3_mmw" "neo" "4" )
CCSchangeParam( "tcoil" "tcoil_master" "schematic" "tcoil3_mmw" "nei" "5" )
lxGenFromSource( cv_schematic )
cv_layout = dbOpenCellViewByType("tcoil" "tcoil_master" "layout")
MovePinsToInstances( cv_schematic cv_layout )
StreamOutGDS("tcoil" "tcoil_master" "layout" "/autofs/fs1.ece/fs1.eecg.tcc/lizongh2/gf22x-1020b/EMX_work/tcoil_tcoil2625.work" "tcoil2625.gds")

cv_schematic = dbOpenCellViewByType("tcoil" "tcoil_master" "schematic")
CCSchangeParam( "tcoil" "tcoil_master" "schematic" "tcoil3_mmw" "pneo" "60" )
CCSchangeParam( "tcoil" "tcoil_master" "schematic" "tcoil3_mmw" "ctapLocation" "bot" )
CCSchangeParam( "tcoil" "tcoil_master" "schematic" "tcoil3_mmw" "od" "40u" )
CCSchangeParam( "tcoil" "tcoil_master" "schematic" "tcoil3_mmw" "w" "4.2u" )
CCSchangeParam( "tcoil" "tcoil_master" "schematic" "tcoil3_mmw" "neo" "6" )
CCSchangeParam( "tcoil" "tcoil_master" "schematic" "tcoil3_mmw" "nei" "5" )
lxGenFromSource( cv_schematic )
cv_layout = dbOpenCellViewByType("tcoil" "tcoil_master" "layout")
MovePinsToInstances( cv_schematic cv_layout )
StreamOutGDS("tcoil" "tcoil_master" "layout" "/autofs/fs1.ece/fs1.eecg.tcc/lizongh2/gf22x-1020b/EMX_work/tcoil_tcoil2626.work" "tcoil2626.gds")

cv_schematic = dbOpenCellViewByType("tcoil" "tcoil_master" "schematic")
CCSchangeParam( "tcoil" "tcoil_master" "schematic" "tcoil3_mmw" "pneo" "60" )
CCSchangeParam( "tcoil" "tcoil_master" "schematic" "tcoil3_mmw" "ctapLocation" "bot" )
CCSchangeParam( "tcoil" "tcoil_master" "schematic" "tcoil3_mmw" "od" "40u" )
CCSchangeParam( "tcoil" "tcoil_master" "schematic" "tcoil3_mmw" "w" "4.2u" )
CCSchangeParam( "tcoil" "tcoil_master" "schematic" "tcoil3_mmw" "neo" "8" )
CCSchangeParam( "tcoil" "tcoil_master" "schematic" "tcoil3_mmw" "nei" "5" )
lxGenFromSource( cv_schematic )
cv_layout = dbOpenCellViewByType("tcoil" "tcoil_master" "layout")
MovePinsToInstances( cv_schematic cv_layout )
StreamOutGDS("tcoil" "tcoil_master" "layout" "/autofs/fs1.ece/fs1.eecg.tcc/lizongh2/gf22x-1020b/EMX_work/tcoil_tcoil2627.work" "tcoil2627.gds")

cv_schematic = dbOpenCellViewByType("tcoil" "tcoil_master" "schematic")
CCSchangeParam( "tcoil" "tcoil_master" "schematic" "tcoil3_mmw" "pneo" "60" )
CCSchangeParam( "tcoil" "tcoil_master" "schematic" "tcoil3_mmw" "ctapLocation" "bot" )
CCSchangeParam( "tcoil" "tcoil_master" "schematic" "tcoil3_mmw" "od" "40u" )
CCSchangeParam( "tcoil" "tcoil_master" "schematic" "tcoil3_mmw" "w" "4.2u" )
CCSchangeParam( "tcoil" "tcoil_master" "schematic" "tcoil3_mmw" "neo" "10" )
CCSchangeParam( "tcoil" "tcoil_master" "schematic" "tcoil3_mmw" "nei" "5" )
lxGenFromSource( cv_schematic )
cv_layout = dbOpenCellViewByType("tcoil" "tcoil_master" "layout")
MovePinsToInstances( cv_schematic cv_layout )
StreamOutGDS("tcoil" "tcoil_master" "layout" "/autofs/fs1.ece/fs1.eecg.tcc/lizongh2/gf22x-1020b/EMX_work/tcoil_tcoil2628.work" "tcoil2628.gds")

cv_schematic = dbOpenCellViewByType("tcoil" "tcoil_master" "schematic")
CCSchangeParam( "tcoil" "tcoil_master" "schematic" "tcoil3_mmw" "pneo" "60" )
CCSchangeParam( "tcoil" "tcoil_master" "schematic" "tcoil3_mmw" "ctapLocation" "bot" )
CCSchangeParam( "tcoil" "tcoil_master" "schematic" "tcoil3_mmw" "od" "40u" )
CCSchangeParam( "tcoil" "tcoil_master" "schematic" "tcoil3_mmw" "w" "4.2u" )
CCSchangeParam( "tcoil" "tcoil_master" "schematic" "tcoil3_mmw" "neo" "12" )
CCSchangeParam( "tcoil" "tcoil_master" "schematic" "tcoil3_mmw" "nei" "5" )
lxGenFromSource( cv_schematic )
cv_layout = dbOpenCellViewByType("tcoil" "tcoil_master" "layout")
MovePinsToInstances( cv_schematic cv_layout )
StreamOutGDS("tcoil" "tcoil_master" "layout" "/autofs/fs1.ece/fs1.eecg.tcc/lizongh2/gf22x-1020b/EMX_work/tcoil_tcoil2629.work" "tcoil2629.gds")

cv_schematic = dbOpenCellViewByType("tcoil" "tcoil_master" "schematic")
CCSchangeParam( "tcoil" "tcoil_master" "schematic" "tcoil3_mmw" "pneo" "60" )
CCSchangeParam( "tcoil" "tcoil_master" "schematic" "tcoil3_mmw" "ctapLocation" "bot" )
CCSchangeParam( "tcoil" "tcoil_master" "schematic" "tcoil3_mmw" "od" "42u" )
CCSchangeParam( "tcoil" "tcoil_master" "schematic" "tcoil3_mmw" "w" "2.4u" )
CCSchangeParam( "tcoil" "tcoil_master" "schematic" "tcoil3_mmw" "neo" "4" )
CCSchangeParam( "tcoil" "tcoil_master" "schematic" "tcoil3_mmw" "nei" "5" )
lxGenFromSource( cv_schematic )
cv_layout = dbOpenCellViewByType("tcoil" "tcoil_master" "layout")
MovePinsToInstances( cv_schematic cv_layout )
StreamOutGDS("tcoil" "tcoil_master" "layout" "/autofs/fs1.ece/fs1.eecg.tcc/lizongh2/gf22x-1020b/EMX_work/tcoil_tcoil2630.work" "tcoil2630.gds")

cv_schematic = dbOpenCellViewByType("tcoil" "tcoil_master" "schematic")
CCSchangeParam( "tcoil" "tcoil_master" "schematic" "tcoil3_mmw" "pneo" "60" )
CCSchangeParam( "tcoil" "tcoil_master" "schematic" "tcoil3_mmw" "ctapLocation" "bot" )
CCSchangeParam( "tcoil" "tcoil_master" "schematic" "tcoil3_mmw" "od" "42u" )
CCSchangeParam( "tcoil" "tcoil_master" "schematic" "tcoil3_mmw" "w" "2.4u" )
CCSchangeParam( "tcoil" "tcoil_master" "schematic" "tcoil3_mmw" "neo" "6" )
CCSchangeParam( "tcoil" "tcoil_master" "schematic" "tcoil3_mmw" "nei" "5" )
lxGenFromSource( cv_schematic )
cv_layout = dbOpenCellViewByType("tcoil" "tcoil_master" "layout")
MovePinsToInstances( cv_schematic cv_layout )
StreamOutGDS("tcoil" "tcoil_master" "layout" "/autofs/fs1.ece/fs1.eecg.tcc/lizongh2/gf22x-1020b/EMX_work/tcoil_tcoil2631.work" "tcoil2631.gds")

cv_schematic = dbOpenCellViewByType("tcoil" "tcoil_master" "schematic")
CCSchangeParam( "tcoil" "tcoil_master" "schematic" "tcoil3_mmw" "pneo" "60" )
CCSchangeParam( "tcoil" "tcoil_master" "schematic" "tcoil3_mmw" "ctapLocation" "bot" )
CCSchangeParam( "tcoil" "tcoil_master" "schematic" "tcoil3_mmw" "od" "42u" )
CCSchangeParam( "tcoil" "tcoil_master" "schematic" "tcoil3_mmw" "w" "2.4u" )
CCSchangeParam( "tcoil" "tcoil_master" "schematic" "tcoil3_mmw" "neo" "8" )
CCSchangeParam( "tcoil" "tcoil_master" "schematic" "tcoil3_mmw" "nei" "5" )
lxGenFromSource( cv_schematic )
cv_layout = dbOpenCellViewByType("tcoil" "tcoil_master" "layout")
MovePinsToInstances( cv_schematic cv_layout )
StreamOutGDS("tcoil" "tcoil_master" "layout" "/autofs/fs1.ece/fs1.eecg.tcc/lizongh2/gf22x-1020b/EMX_work/tcoil_tcoil2632.work" "tcoil2632.gds")

cv_schematic = dbOpenCellViewByType("tcoil" "tcoil_master" "schematic")
CCSchangeParam( "tcoil" "tcoil_master" "schematic" "tcoil3_mmw" "pneo" "60" )
CCSchangeParam( "tcoil" "tcoil_master" "schematic" "tcoil3_mmw" "ctapLocation" "bot" )
CCSchangeParam( "tcoil" "tcoil_master" "schematic" "tcoil3_mmw" "od" "42u" )
CCSchangeParam( "tcoil" "tcoil_master" "schematic" "tcoil3_mmw" "w" "2.4u" )
CCSchangeParam( "tcoil" "tcoil_master" "schematic" "tcoil3_mmw" "neo" "10" )
CCSchangeParam( "tcoil" "tcoil_master" "schematic" "tcoil3_mmw" "nei" "5" )
lxGenFromSource( cv_schematic )
cv_layout = dbOpenCellViewByType("tcoil" "tcoil_master" "layout")
MovePinsToInstances( cv_schematic cv_layout )
StreamOutGDS("tcoil" "tcoil_master" "layout" "/autofs/fs1.ece/fs1.eecg.tcc/lizongh2/gf22x-1020b/EMX_work/tcoil_tcoil2633.work" "tcoil2633.gds")

cv_schematic = dbOpenCellViewByType("tcoil" "tcoil_master" "schematic")
CCSchangeParam( "tcoil" "tcoil_master" "schematic" "tcoil3_mmw" "pneo" "60" )
CCSchangeParam( "tcoil" "tcoil_master" "schematic" "tcoil3_mmw" "ctapLocation" "bot" )
CCSchangeParam( "tcoil" "tcoil_master" "schematic" "tcoil3_mmw" "od" "42u" )
CCSchangeParam( "tcoil" "tcoil_master" "schematic" "tcoil3_mmw" "w" "2.4u" )
CCSchangeParam( "tcoil" "tcoil_master" "schematic" "tcoil3_mmw" "neo" "12" )
CCSchangeParam( "tcoil" "tcoil_master" "schematic" "tcoil3_mmw" "nei" "5" )
lxGenFromSource( cv_schematic )
cv_layout = dbOpenCellViewByType("tcoil" "tcoil_master" "layout")
MovePinsToInstances( cv_schematic cv_layout )
StreamOutGDS("tcoil" "tcoil_master" "layout" "/autofs/fs1.ece/fs1.eecg.tcc/lizongh2/gf22x-1020b/EMX_work/tcoil_tcoil2634.work" "tcoil2634.gds")

cv_schematic = dbOpenCellViewByType("tcoil" "tcoil_master" "schematic")
CCSchangeParam( "tcoil" "tcoil_master" "schematic" "tcoil3_mmw" "pneo" "60" )
CCSchangeParam( "tcoil" "tcoil_master" "schematic" "tcoil3_mmw" "ctapLocation" "bot" )
CCSchangeParam( "tcoil" "tcoil_master" "schematic" "tcoil3_mmw" "od" "42u" )
CCSchangeParam( "tcoil" "tcoil_master" "schematic" "tcoil3_mmw" "w" "4.2u" )
CCSchangeParam( "tcoil" "tcoil_master" "schematic" "tcoil3_mmw" "neo" "4" )
CCSchangeParam( "tcoil" "tcoil_master" "schematic" "tcoil3_mmw" "nei" "5" )
lxGenFromSource( cv_schematic )
cv_layout = dbOpenCellViewByType("tcoil" "tcoil_master" "layout")
MovePinsToInstances( cv_schematic cv_layout )
StreamOutGDS("tcoil" "tcoil_master" "layout" "/autofs/fs1.ece/fs1.eecg.tcc/lizongh2/gf22x-1020b/EMX_work/tcoil_tcoil2635.work" "tcoil2635.gds")

cv_schematic = dbOpenCellViewByType("tcoil" "tcoil_master" "schematic")
CCSchangeParam( "tcoil" "tcoil_master" "schematic" "tcoil3_mmw" "pneo" "60" )
CCSchangeParam( "tcoil" "tcoil_master" "schematic" "tcoil3_mmw" "ctapLocation" "bot" )
CCSchangeParam( "tcoil" "tcoil_master" "schematic" "tcoil3_mmw" "od" "42u" )
CCSchangeParam( "tcoil" "tcoil_master" "schematic" "tcoil3_mmw" "w" "4.2u" )
CCSchangeParam( "tcoil" "tcoil_master" "schematic" "tcoil3_mmw" "neo" "6" )
CCSchangeParam( "tcoil" "tcoil_master" "schematic" "tcoil3_mmw" "nei" "5" )
lxGenFromSource( cv_schematic )
cv_layout = dbOpenCellViewByType("tcoil" "tcoil_master" "layout")
MovePinsToInstances( cv_schematic cv_layout )
StreamOutGDS("tcoil" "tcoil_master" "layout" "/autofs/fs1.ece/fs1.eecg.tcc/lizongh2/gf22x-1020b/EMX_work/tcoil_tcoil2636.work" "tcoil2636.gds")

cv_schematic = dbOpenCellViewByType("tcoil" "tcoil_master" "schematic")
CCSchangeParam( "tcoil" "tcoil_master" "schematic" "tcoil3_mmw" "pneo" "60" )
CCSchangeParam( "tcoil" "tcoil_master" "schematic" "tcoil3_mmw" "ctapLocation" "bot" )
CCSchangeParam( "tcoil" "tcoil_master" "schematic" "tcoil3_mmw" "od" "42u" )
CCSchangeParam( "tcoil" "tcoil_master" "schematic" "tcoil3_mmw" "w" "4.2u" )
CCSchangeParam( "tcoil" "tcoil_master" "schematic" "tcoil3_mmw" "neo" "8" )
CCSchangeParam( "tcoil" "tcoil_master" "schematic" "tcoil3_mmw" "nei" "5" )
lxGenFromSource( cv_schematic )
cv_layout = dbOpenCellViewByType("tcoil" "tcoil_master" "layout")
MovePinsToInstances( cv_schematic cv_layout )
StreamOutGDS("tcoil" "tcoil_master" "layout" "/autofs/fs1.ece/fs1.eecg.tcc/lizongh2/gf22x-1020b/EMX_work/tcoil_tcoil2637.work" "tcoil2637.gds")

cv_schematic = dbOpenCellViewByType("tcoil" "tcoil_master" "schematic")
CCSchangeParam( "tcoil" "tcoil_master" "schematic" "tcoil3_mmw" "pneo" "60" )
CCSchangeParam( "tcoil" "tcoil_master" "schematic" "tcoil3_mmw" "ctapLocation" "bot" )
CCSchangeParam( "tcoil" "tcoil_master" "schematic" "tcoil3_mmw" "od" "42u" )
CCSchangeParam( "tcoil" "tcoil_master" "schematic" "tcoil3_mmw" "w" "4.2u" )
CCSchangeParam( "tcoil" "tcoil_master" "schematic" "tcoil3_mmw" "neo" "10" )
CCSchangeParam( "tcoil" "tcoil_master" "schematic" "tcoil3_mmw" "nei" "5" )
lxGenFromSource( cv_schematic )
cv_layout = dbOpenCellViewByType("tcoil" "tcoil_master" "layout")
MovePinsToInstances( cv_schematic cv_layout )
StreamOutGDS("tcoil" "tcoil_master" "layout" "/autofs/fs1.ece/fs1.eecg.tcc/lizongh2/gf22x-1020b/EMX_work/tcoil_tcoil2638.work" "tcoil2638.gds")

cv_schematic = dbOpenCellViewByType("tcoil" "tcoil_master" "schematic")
CCSchangeParam( "tcoil" "tcoil_master" "schematic" "tcoil3_mmw" "pneo" "60" )
CCSchangeParam( "tcoil" "tcoil_master" "schematic" "tcoil3_mmw" "ctapLocation" "bot" )
CCSchangeParam( "tcoil" "tcoil_master" "schematic" "tcoil3_mmw" "od" "42u" )
CCSchangeParam( "tcoil" "tcoil_master" "schematic" "tcoil3_mmw" "w" "4.2u" )
CCSchangeParam( "tcoil" "tcoil_master" "schematic" "tcoil3_mmw" "neo" "12" )
CCSchangeParam( "tcoil" "tcoil_master" "schematic" "tcoil3_mmw" "nei" "5" )
lxGenFromSource( cv_schematic )
cv_layout = dbOpenCellViewByType("tcoil" "tcoil_master" "layout")
MovePinsToInstances( cv_schematic cv_layout )
StreamOutGDS("tcoil" "tcoil_master" "layout" "/autofs/fs1.ece/fs1.eecg.tcc/lizongh2/gf22x-1020b/EMX_work/tcoil_tcoil2639.work" "tcoil2639.gds")

cv_schematic = dbOpenCellViewByType("tcoil" "tcoil_master" "schematic")
CCSchangeParam( "tcoil" "tcoil_master" "schematic" "tcoil3_mmw" "pneo" "60" )
CCSchangeParam( "tcoil" "tcoil_master" "schematic" "tcoil3_mmw" "ctapLocation" "bot" )
CCSchangeParam( "tcoil" "tcoil_master" "schematic" "tcoil3_mmw" "od" "44u" )
CCSchangeParam( "tcoil" "tcoil_master" "schematic" "tcoil3_mmw" "w" "2.4u" )
CCSchangeParam( "tcoil" "tcoil_master" "schematic" "tcoil3_mmw" "neo" "4" )
CCSchangeParam( "tcoil" "tcoil_master" "schematic" "tcoil3_mmw" "nei" "5" )
lxGenFromSource( cv_schematic )
cv_layout = dbOpenCellViewByType("tcoil" "tcoil_master" "layout")
MovePinsToInstances( cv_schematic cv_layout )
StreamOutGDS("tcoil" "tcoil_master" "layout" "/autofs/fs1.ece/fs1.eecg.tcc/lizongh2/gf22x-1020b/EMX_work/tcoil_tcoil2640.work" "tcoil2640.gds")

cv_schematic = dbOpenCellViewByType("tcoil" "tcoil_master" "schematic")
CCSchangeParam( "tcoil" "tcoil_master" "schematic" "tcoil3_mmw" "pneo" "60" )
CCSchangeParam( "tcoil" "tcoil_master" "schematic" "tcoil3_mmw" "ctapLocation" "bot" )
CCSchangeParam( "tcoil" "tcoil_master" "schematic" "tcoil3_mmw" "od" "44u" )
CCSchangeParam( "tcoil" "tcoil_master" "schematic" "tcoil3_mmw" "w" "2.4u" )
CCSchangeParam( "tcoil" "tcoil_master" "schematic" "tcoil3_mmw" "neo" "6" )
CCSchangeParam( "tcoil" "tcoil_master" "schematic" "tcoil3_mmw" "nei" "5" )
lxGenFromSource( cv_schematic )
cv_layout = dbOpenCellViewByType("tcoil" "tcoil_master" "layout")
MovePinsToInstances( cv_schematic cv_layout )
StreamOutGDS("tcoil" "tcoil_master" "layout" "/autofs/fs1.ece/fs1.eecg.tcc/lizongh2/gf22x-1020b/EMX_work/tcoil_tcoil2641.work" "tcoil2641.gds")

cv_schematic = dbOpenCellViewByType("tcoil" "tcoil_master" "schematic")
CCSchangeParam( "tcoil" "tcoil_master" "schematic" "tcoil3_mmw" "pneo" "60" )
CCSchangeParam( "tcoil" "tcoil_master" "schematic" "tcoil3_mmw" "ctapLocation" "bot" )
CCSchangeParam( "tcoil" "tcoil_master" "schematic" "tcoil3_mmw" "od" "44u" )
CCSchangeParam( "tcoil" "tcoil_master" "schematic" "tcoil3_mmw" "w" "2.4u" )
CCSchangeParam( "tcoil" "tcoil_master" "schematic" "tcoil3_mmw" "neo" "8" )
CCSchangeParam( "tcoil" "tcoil_master" "schematic" "tcoil3_mmw" "nei" "5" )
lxGenFromSource( cv_schematic )
cv_layout = dbOpenCellViewByType("tcoil" "tcoil_master" "layout")
MovePinsToInstances( cv_schematic cv_layout )
StreamOutGDS("tcoil" "tcoil_master" "layout" "/autofs/fs1.ece/fs1.eecg.tcc/lizongh2/gf22x-1020b/EMX_work/tcoil_tcoil2642.work" "tcoil2642.gds")

cv_schematic = dbOpenCellViewByType("tcoil" "tcoil_master" "schematic")
CCSchangeParam( "tcoil" "tcoil_master" "schematic" "tcoil3_mmw" "pneo" "60" )
CCSchangeParam( "tcoil" "tcoil_master" "schematic" "tcoil3_mmw" "ctapLocation" "bot" )
CCSchangeParam( "tcoil" "tcoil_master" "schematic" "tcoil3_mmw" "od" "44u" )
CCSchangeParam( "tcoil" "tcoil_master" "schematic" "tcoil3_mmw" "w" "2.4u" )
CCSchangeParam( "tcoil" "tcoil_master" "schematic" "tcoil3_mmw" "neo" "10" )
CCSchangeParam( "tcoil" "tcoil_master" "schematic" "tcoil3_mmw" "nei" "5" )
lxGenFromSource( cv_schematic )
cv_layout = dbOpenCellViewByType("tcoil" "tcoil_master" "layout")
MovePinsToInstances( cv_schematic cv_layout )
StreamOutGDS("tcoil" "tcoil_master" "layout" "/autofs/fs1.ece/fs1.eecg.tcc/lizongh2/gf22x-1020b/EMX_work/tcoil_tcoil2643.work" "tcoil2643.gds")

cv_schematic = dbOpenCellViewByType("tcoil" "tcoil_master" "schematic")
CCSchangeParam( "tcoil" "tcoil_master" "schematic" "tcoil3_mmw" "pneo" "60" )
CCSchangeParam( "tcoil" "tcoil_master" "schematic" "tcoil3_mmw" "ctapLocation" "bot" )
CCSchangeParam( "tcoil" "tcoil_master" "schematic" "tcoil3_mmw" "od" "44u" )
CCSchangeParam( "tcoil" "tcoil_master" "schematic" "tcoil3_mmw" "w" "2.4u" )
CCSchangeParam( "tcoil" "tcoil_master" "schematic" "tcoil3_mmw" "neo" "12" )
CCSchangeParam( "tcoil" "tcoil_master" "schematic" "tcoil3_mmw" "nei" "5" )
lxGenFromSource( cv_schematic )
cv_layout = dbOpenCellViewByType("tcoil" "tcoil_master" "layout")
MovePinsToInstances( cv_schematic cv_layout )
StreamOutGDS("tcoil" "tcoil_master" "layout" "/autofs/fs1.ece/fs1.eecg.tcc/lizongh2/gf22x-1020b/EMX_work/tcoil_tcoil2644.work" "tcoil2644.gds")

cv_schematic = dbOpenCellViewByType("tcoil" "tcoil_master" "schematic")
CCSchangeParam( "tcoil" "tcoil_master" "schematic" "tcoil3_mmw" "pneo" "60" )
CCSchangeParam( "tcoil" "tcoil_master" "schematic" "tcoil3_mmw" "ctapLocation" "bot" )
CCSchangeParam( "tcoil" "tcoil_master" "schematic" "tcoil3_mmw" "od" "44u" )
CCSchangeParam( "tcoil" "tcoil_master" "schematic" "tcoil3_mmw" "w" "4.2u" )
CCSchangeParam( "tcoil" "tcoil_master" "schematic" "tcoil3_mmw" "neo" "4" )
CCSchangeParam( "tcoil" "tcoil_master" "schematic" "tcoil3_mmw" "nei" "5" )
lxGenFromSource( cv_schematic )
cv_layout = dbOpenCellViewByType("tcoil" "tcoil_master" "layout")
MovePinsToInstances( cv_schematic cv_layout )
StreamOutGDS("tcoil" "tcoil_master" "layout" "/autofs/fs1.ece/fs1.eecg.tcc/lizongh2/gf22x-1020b/EMX_work/tcoil_tcoil2645.work" "tcoil2645.gds")

cv_schematic = dbOpenCellViewByType("tcoil" "tcoil_master" "schematic")
CCSchangeParam( "tcoil" "tcoil_master" "schematic" "tcoil3_mmw" "pneo" "60" )
CCSchangeParam( "tcoil" "tcoil_master" "schematic" "tcoil3_mmw" "ctapLocation" "bot" )
CCSchangeParam( "tcoil" "tcoil_master" "schematic" "tcoil3_mmw" "od" "44u" )
CCSchangeParam( "tcoil" "tcoil_master" "schematic" "tcoil3_mmw" "w" "4.2u" )
CCSchangeParam( "tcoil" "tcoil_master" "schematic" "tcoil3_mmw" "neo" "6" )
CCSchangeParam( "tcoil" "tcoil_master" "schematic" "tcoil3_mmw" "nei" "5" )
lxGenFromSource( cv_schematic )
cv_layout = dbOpenCellViewByType("tcoil" "tcoil_master" "layout")
MovePinsToInstances( cv_schematic cv_layout )
StreamOutGDS("tcoil" "tcoil_master" "layout" "/autofs/fs1.ece/fs1.eecg.tcc/lizongh2/gf22x-1020b/EMX_work/tcoil_tcoil2646.work" "tcoil2646.gds")

cv_schematic = dbOpenCellViewByType("tcoil" "tcoil_master" "schematic")
CCSchangeParam( "tcoil" "tcoil_master" "schematic" "tcoil3_mmw" "pneo" "60" )
CCSchangeParam( "tcoil" "tcoil_master" "schematic" "tcoil3_mmw" "ctapLocation" "bot" )
CCSchangeParam( "tcoil" "tcoil_master" "schematic" "tcoil3_mmw" "od" "44u" )
CCSchangeParam( "tcoil" "tcoil_master" "schematic" "tcoil3_mmw" "w" "4.2u" )
CCSchangeParam( "tcoil" "tcoil_master" "schematic" "tcoil3_mmw" "neo" "8" )
CCSchangeParam( "tcoil" "tcoil_master" "schematic" "tcoil3_mmw" "nei" "5" )
lxGenFromSource( cv_schematic )
cv_layout = dbOpenCellViewByType("tcoil" "tcoil_master" "layout")
MovePinsToInstances( cv_schematic cv_layout )
StreamOutGDS("tcoil" "tcoil_master" "layout" "/autofs/fs1.ece/fs1.eecg.tcc/lizongh2/gf22x-1020b/EMX_work/tcoil_tcoil2647.work" "tcoil2647.gds")

cv_schematic = dbOpenCellViewByType("tcoil" "tcoil_master" "schematic")
CCSchangeParam( "tcoil" "tcoil_master" "schematic" "tcoil3_mmw" "pneo" "60" )
CCSchangeParam( "tcoil" "tcoil_master" "schematic" "tcoil3_mmw" "ctapLocation" "bot" )
CCSchangeParam( "tcoil" "tcoil_master" "schematic" "tcoil3_mmw" "od" "44u" )
CCSchangeParam( "tcoil" "tcoil_master" "schematic" "tcoil3_mmw" "w" "4.2u" )
CCSchangeParam( "tcoil" "tcoil_master" "schematic" "tcoil3_mmw" "neo" "10" )
CCSchangeParam( "tcoil" "tcoil_master" "schematic" "tcoil3_mmw" "nei" "5" )
lxGenFromSource( cv_schematic )
cv_layout = dbOpenCellViewByType("tcoil" "tcoil_master" "layout")
MovePinsToInstances( cv_schematic cv_layout )
StreamOutGDS("tcoil" "tcoil_master" "layout" "/autofs/fs1.ece/fs1.eecg.tcc/lizongh2/gf22x-1020b/EMX_work/tcoil_tcoil2648.work" "tcoil2648.gds")

cv_schematic = dbOpenCellViewByType("tcoil" "tcoil_master" "schematic")
CCSchangeParam( "tcoil" "tcoil_master" "schematic" "tcoil3_mmw" "pneo" "60" )
CCSchangeParam( "tcoil" "tcoil_master" "schematic" "tcoil3_mmw" "ctapLocation" "bot" )
CCSchangeParam( "tcoil" "tcoil_master" "schematic" "tcoil3_mmw" "od" "44u" )
CCSchangeParam( "tcoil" "tcoil_master" "schematic" "tcoil3_mmw" "w" "4.2u" )
CCSchangeParam( "tcoil" "tcoil_master" "schematic" "tcoil3_mmw" "neo" "12" )
CCSchangeParam( "tcoil" "tcoil_master" "schematic" "tcoil3_mmw" "nei" "5" )
lxGenFromSource( cv_schematic )
cv_layout = dbOpenCellViewByType("tcoil" "tcoil_master" "layout")
MovePinsToInstances( cv_schematic cv_layout )
StreamOutGDS("tcoil" "tcoil_master" "layout" "/autofs/fs1.ece/fs1.eecg.tcc/lizongh2/gf22x-1020b/EMX_work/tcoil_tcoil2649.work" "tcoil2649.gds")

cv_schematic = dbOpenCellViewByType("tcoil" "tcoil_master" "schematic")
CCSchangeParam( "tcoil" "tcoil_master" "schematic" "tcoil3_mmw" "pneo" "60" )
CCSchangeParam( "tcoil" "tcoil_master" "schematic" "tcoil3_mmw" "ctapLocation" "bot" )
CCSchangeParam( "tcoil" "tcoil_master" "schematic" "tcoil3_mmw" "od" "46u" )
CCSchangeParam( "tcoil" "tcoil_master" "schematic" "tcoil3_mmw" "w" "2.4u" )
CCSchangeParam( "tcoil" "tcoil_master" "schematic" "tcoil3_mmw" "neo" "4" )
CCSchangeParam( "tcoil" "tcoil_master" "schematic" "tcoil3_mmw" "nei" "5" )
lxGenFromSource( cv_schematic )
cv_layout = dbOpenCellViewByType("tcoil" "tcoil_master" "layout")
MovePinsToInstances( cv_schematic cv_layout )
StreamOutGDS("tcoil" "tcoil_master" "layout" "/autofs/fs1.ece/fs1.eecg.tcc/lizongh2/gf22x-1020b/EMX_work/tcoil_tcoil2650.work" "tcoil2650.gds")

cv_schematic = dbOpenCellViewByType("tcoil" "tcoil_master" "schematic")
CCSchangeParam( "tcoil" "tcoil_master" "schematic" "tcoil3_mmw" "pneo" "60" )
CCSchangeParam( "tcoil" "tcoil_master" "schematic" "tcoil3_mmw" "ctapLocation" "bot" )
CCSchangeParam( "tcoil" "tcoil_master" "schematic" "tcoil3_mmw" "od" "46u" )
CCSchangeParam( "tcoil" "tcoil_master" "schematic" "tcoil3_mmw" "w" "2.4u" )
CCSchangeParam( "tcoil" "tcoil_master" "schematic" "tcoil3_mmw" "neo" "6" )
CCSchangeParam( "tcoil" "tcoil_master" "schematic" "tcoil3_mmw" "nei" "5" )
lxGenFromSource( cv_schematic )
cv_layout = dbOpenCellViewByType("tcoil" "tcoil_master" "layout")
MovePinsToInstances( cv_schematic cv_layout )
StreamOutGDS("tcoil" "tcoil_master" "layout" "/autofs/fs1.ece/fs1.eecg.tcc/lizongh2/gf22x-1020b/EMX_work/tcoil_tcoil2651.work" "tcoil2651.gds")

cv_schematic = dbOpenCellViewByType("tcoil" "tcoil_master" "schematic")
CCSchangeParam( "tcoil" "tcoil_master" "schematic" "tcoil3_mmw" "pneo" "60" )
CCSchangeParam( "tcoil" "tcoil_master" "schematic" "tcoil3_mmw" "ctapLocation" "bot" )
CCSchangeParam( "tcoil" "tcoil_master" "schematic" "tcoil3_mmw" "od" "46u" )
CCSchangeParam( "tcoil" "tcoil_master" "schematic" "tcoil3_mmw" "w" "2.4u" )
CCSchangeParam( "tcoil" "tcoil_master" "schematic" "tcoil3_mmw" "neo" "8" )
CCSchangeParam( "tcoil" "tcoil_master" "schematic" "tcoil3_mmw" "nei" "5" )
lxGenFromSource( cv_schematic )
cv_layout = dbOpenCellViewByType("tcoil" "tcoil_master" "layout")
MovePinsToInstances( cv_schematic cv_layout )
StreamOutGDS("tcoil" "tcoil_master" "layout" "/autofs/fs1.ece/fs1.eecg.tcc/lizongh2/gf22x-1020b/EMX_work/tcoil_tcoil2652.work" "tcoil2652.gds")

cv_schematic = dbOpenCellViewByType("tcoil" "tcoil_master" "schematic")
CCSchangeParam( "tcoil" "tcoil_master" "schematic" "tcoil3_mmw" "pneo" "60" )
CCSchangeParam( "tcoil" "tcoil_master" "schematic" "tcoil3_mmw" "ctapLocation" "bot" )
CCSchangeParam( "tcoil" "tcoil_master" "schematic" "tcoil3_mmw" "od" "46u" )
CCSchangeParam( "tcoil" "tcoil_master" "schematic" "tcoil3_mmw" "w" "2.4u" )
CCSchangeParam( "tcoil" "tcoil_master" "schematic" "tcoil3_mmw" "neo" "10" )
CCSchangeParam( "tcoil" "tcoil_master" "schematic" "tcoil3_mmw" "nei" "5" )
lxGenFromSource( cv_schematic )
cv_layout = dbOpenCellViewByType("tcoil" "tcoil_master" "layout")
MovePinsToInstances( cv_schematic cv_layout )
StreamOutGDS("tcoil" "tcoil_master" "layout" "/autofs/fs1.ece/fs1.eecg.tcc/lizongh2/gf22x-1020b/EMX_work/tcoil_tcoil2653.work" "tcoil2653.gds")

cv_schematic = dbOpenCellViewByType("tcoil" "tcoil_master" "schematic")
CCSchangeParam( "tcoil" "tcoil_master" "schematic" "tcoil3_mmw" "pneo" "60" )
CCSchangeParam( "tcoil" "tcoil_master" "schematic" "tcoil3_mmw" "ctapLocation" "bot" )
CCSchangeParam( "tcoil" "tcoil_master" "schematic" "tcoil3_mmw" "od" "46u" )
CCSchangeParam( "tcoil" "tcoil_master" "schematic" "tcoil3_mmw" "w" "2.4u" )
CCSchangeParam( "tcoil" "tcoil_master" "schematic" "tcoil3_mmw" "neo" "12" )
CCSchangeParam( "tcoil" "tcoil_master" "schematic" "tcoil3_mmw" "nei" "5" )
lxGenFromSource( cv_schematic )
cv_layout = dbOpenCellViewByType("tcoil" "tcoil_master" "layout")
MovePinsToInstances( cv_schematic cv_layout )
StreamOutGDS("tcoil" "tcoil_master" "layout" "/autofs/fs1.ece/fs1.eecg.tcc/lizongh2/gf22x-1020b/EMX_work/tcoil_tcoil2654.work" "tcoil2654.gds")

cv_schematic = dbOpenCellViewByType("tcoil" "tcoil_master" "schematic")
CCSchangeParam( "tcoil" "tcoil_master" "schematic" "tcoil3_mmw" "pneo" "60" )
CCSchangeParam( "tcoil" "tcoil_master" "schematic" "tcoil3_mmw" "ctapLocation" "bot" )
CCSchangeParam( "tcoil" "tcoil_master" "schematic" "tcoil3_mmw" "od" "46u" )
CCSchangeParam( "tcoil" "tcoil_master" "schematic" "tcoil3_mmw" "w" "4.2u" )
CCSchangeParam( "tcoil" "tcoil_master" "schematic" "tcoil3_mmw" "neo" "4" )
CCSchangeParam( "tcoil" "tcoil_master" "schematic" "tcoil3_mmw" "nei" "5" )
lxGenFromSource( cv_schematic )
cv_layout = dbOpenCellViewByType("tcoil" "tcoil_master" "layout")
MovePinsToInstances( cv_schematic cv_layout )
StreamOutGDS("tcoil" "tcoil_master" "layout" "/autofs/fs1.ece/fs1.eecg.tcc/lizongh2/gf22x-1020b/EMX_work/tcoil_tcoil2655.work" "tcoil2655.gds")

cv_schematic = dbOpenCellViewByType("tcoil" "tcoil_master" "schematic")
CCSchangeParam( "tcoil" "tcoil_master" "schematic" "tcoil3_mmw" "pneo" "60" )
CCSchangeParam( "tcoil" "tcoil_master" "schematic" "tcoil3_mmw" "ctapLocation" "bot" )
CCSchangeParam( "tcoil" "tcoil_master" "schematic" "tcoil3_mmw" "od" "46u" )
CCSchangeParam( "tcoil" "tcoil_master" "schematic" "tcoil3_mmw" "w" "4.2u" )
CCSchangeParam( "tcoil" "tcoil_master" "schematic" "tcoil3_mmw" "neo" "6" )
CCSchangeParam( "tcoil" "tcoil_master" "schematic" "tcoil3_mmw" "nei" "5" )
lxGenFromSource( cv_schematic )
cv_layout = dbOpenCellViewByType("tcoil" "tcoil_master" "layout")
MovePinsToInstances( cv_schematic cv_layout )
StreamOutGDS("tcoil" "tcoil_master" "layout" "/autofs/fs1.ece/fs1.eecg.tcc/lizongh2/gf22x-1020b/EMX_work/tcoil_tcoil2656.work" "tcoil2656.gds")

cv_schematic = dbOpenCellViewByType("tcoil" "tcoil_master" "schematic")
CCSchangeParam( "tcoil" "tcoil_master" "schematic" "tcoil3_mmw" "pneo" "60" )
CCSchangeParam( "tcoil" "tcoil_master" "schematic" "tcoil3_mmw" "ctapLocation" "bot" )
CCSchangeParam( "tcoil" "tcoil_master" "schematic" "tcoil3_mmw" "od" "46u" )
CCSchangeParam( "tcoil" "tcoil_master" "schematic" "tcoil3_mmw" "w" "4.2u" )
CCSchangeParam( "tcoil" "tcoil_master" "schematic" "tcoil3_mmw" "neo" "8" )
CCSchangeParam( "tcoil" "tcoil_master" "schematic" "tcoil3_mmw" "nei" "5" )
lxGenFromSource( cv_schematic )
cv_layout = dbOpenCellViewByType("tcoil" "tcoil_master" "layout")
MovePinsToInstances( cv_schematic cv_layout )
StreamOutGDS("tcoil" "tcoil_master" "layout" "/autofs/fs1.ece/fs1.eecg.tcc/lizongh2/gf22x-1020b/EMX_work/tcoil_tcoil2657.work" "tcoil2657.gds")

cv_schematic = dbOpenCellViewByType("tcoil" "tcoil_master" "schematic")
CCSchangeParam( "tcoil" "tcoil_master" "schematic" "tcoil3_mmw" "pneo" "60" )
CCSchangeParam( "tcoil" "tcoil_master" "schematic" "tcoil3_mmw" "ctapLocation" "bot" )
CCSchangeParam( "tcoil" "tcoil_master" "schematic" "tcoil3_mmw" "od" "46u" )
CCSchangeParam( "tcoil" "tcoil_master" "schematic" "tcoil3_mmw" "w" "4.2u" )
CCSchangeParam( "tcoil" "tcoil_master" "schematic" "tcoil3_mmw" "neo" "10" )
CCSchangeParam( "tcoil" "tcoil_master" "schematic" "tcoil3_mmw" "nei" "5" )
lxGenFromSource( cv_schematic )
cv_layout = dbOpenCellViewByType("tcoil" "tcoil_master" "layout")
MovePinsToInstances( cv_schematic cv_layout )
StreamOutGDS("tcoil" "tcoil_master" "layout" "/autofs/fs1.ece/fs1.eecg.tcc/lizongh2/gf22x-1020b/EMX_work/tcoil_tcoil2658.work" "tcoil2658.gds")

cv_schematic = dbOpenCellViewByType("tcoil" "tcoil_master" "schematic")
CCSchangeParam( "tcoil" "tcoil_master" "schematic" "tcoil3_mmw" "pneo" "60" )
CCSchangeParam( "tcoil" "tcoil_master" "schematic" "tcoil3_mmw" "ctapLocation" "bot" )
CCSchangeParam( "tcoil" "tcoil_master" "schematic" "tcoil3_mmw" "od" "46u" )
CCSchangeParam( "tcoil" "tcoil_master" "schematic" "tcoil3_mmw" "w" "4.2u" )
CCSchangeParam( "tcoil" "tcoil_master" "schematic" "tcoil3_mmw" "neo" "12" )
CCSchangeParam( "tcoil" "tcoil_master" "schematic" "tcoil3_mmw" "nei" "5" )
lxGenFromSource( cv_schematic )
cv_layout = dbOpenCellViewByType("tcoil" "tcoil_master" "layout")
MovePinsToInstances( cv_schematic cv_layout )
StreamOutGDS("tcoil" "tcoil_master" "layout" "/autofs/fs1.ece/fs1.eecg.tcc/lizongh2/gf22x-1020b/EMX_work/tcoil_tcoil2659.work" "tcoil2659.gds")

cv_schematic = dbOpenCellViewByType("tcoil" "tcoil_master" "schematic")
CCSchangeParam( "tcoil" "tcoil_master" "schematic" "tcoil3_mmw" "pneo" "60" )
CCSchangeParam( "tcoil" "tcoil_master" "schematic" "tcoil3_mmw" "ctapLocation" "bot" )
CCSchangeParam( "tcoil" "tcoil_master" "schematic" "tcoil3_mmw" "od" "46u" )
CCSchangeParam( "tcoil" "tcoil_master" "schematic" "tcoil3_mmw" "w" "5.0u" )
CCSchangeParam( "tcoil" "tcoil_master" "schematic" "tcoil3_mmw" "neo" "4" )
CCSchangeParam( "tcoil" "tcoil_master" "schematic" "tcoil3_mmw" "nei" "5" )
lxGenFromSource( cv_schematic )
cv_layout = dbOpenCellViewByType("tcoil" "tcoil_master" "layout")
MovePinsToInstances( cv_schematic cv_layout )
StreamOutGDS("tcoil" "tcoil_master" "layout" "/autofs/fs1.ece/fs1.eecg.tcc/lizongh2/gf22x-1020b/EMX_work/tcoil_tcoil2660.work" "tcoil2660.gds")

cv_schematic = dbOpenCellViewByType("tcoil" "tcoil_master" "schematic")
CCSchangeParam( "tcoil" "tcoil_master" "schematic" "tcoil3_mmw" "pneo" "60" )
CCSchangeParam( "tcoil" "tcoil_master" "schematic" "tcoil3_mmw" "ctapLocation" "bot" )
CCSchangeParam( "tcoil" "tcoil_master" "schematic" "tcoil3_mmw" "od" "46u" )
CCSchangeParam( "tcoil" "tcoil_master" "schematic" "tcoil3_mmw" "w" "5.0u" )
CCSchangeParam( "tcoil" "tcoil_master" "schematic" "tcoil3_mmw" "neo" "6" )
CCSchangeParam( "tcoil" "tcoil_master" "schematic" "tcoil3_mmw" "nei" "5" )
lxGenFromSource( cv_schematic )
cv_layout = dbOpenCellViewByType("tcoil" "tcoil_master" "layout")
MovePinsToInstances( cv_schematic cv_layout )
StreamOutGDS("tcoil" "tcoil_master" "layout" "/autofs/fs1.ece/fs1.eecg.tcc/lizongh2/gf22x-1020b/EMX_work/tcoil_tcoil2661.work" "tcoil2661.gds")

cv_schematic = dbOpenCellViewByType("tcoil" "tcoil_master" "schematic")
CCSchangeParam( "tcoil" "tcoil_master" "schematic" "tcoil3_mmw" "pneo" "60" )
CCSchangeParam( "tcoil" "tcoil_master" "schematic" "tcoil3_mmw" "ctapLocation" "bot" )
CCSchangeParam( "tcoil" "tcoil_master" "schematic" "tcoil3_mmw" "od" "46u" )
CCSchangeParam( "tcoil" "tcoil_master" "schematic" "tcoil3_mmw" "w" "5.0u" )
CCSchangeParam( "tcoil" "tcoil_master" "schematic" "tcoil3_mmw" "neo" "8" )
CCSchangeParam( "tcoil" "tcoil_master" "schematic" "tcoil3_mmw" "nei" "5" )
lxGenFromSource( cv_schematic )
cv_layout = dbOpenCellViewByType("tcoil" "tcoil_master" "layout")
MovePinsToInstances( cv_schematic cv_layout )
StreamOutGDS("tcoil" "tcoil_master" "layout" "/autofs/fs1.ece/fs1.eecg.tcc/lizongh2/gf22x-1020b/EMX_work/tcoil_tcoil2662.work" "tcoil2662.gds")

cv_schematic = dbOpenCellViewByType("tcoil" "tcoil_master" "schematic")
CCSchangeParam( "tcoil" "tcoil_master" "schematic" "tcoil3_mmw" "pneo" "60" )
CCSchangeParam( "tcoil" "tcoil_master" "schematic" "tcoil3_mmw" "ctapLocation" "bot" )
CCSchangeParam( "tcoil" "tcoil_master" "schematic" "tcoil3_mmw" "od" "46u" )
CCSchangeParam( "tcoil" "tcoil_master" "schematic" "tcoil3_mmw" "w" "5.0u" )
CCSchangeParam( "tcoil" "tcoil_master" "schematic" "tcoil3_mmw" "neo" "10" )
CCSchangeParam( "tcoil" "tcoil_master" "schematic" "tcoil3_mmw" "nei" "5" )
lxGenFromSource( cv_schematic )
cv_layout = dbOpenCellViewByType("tcoil" "tcoil_master" "layout")
MovePinsToInstances( cv_schematic cv_layout )
StreamOutGDS("tcoil" "tcoil_master" "layout" "/autofs/fs1.ece/fs1.eecg.tcc/lizongh2/gf22x-1020b/EMX_work/tcoil_tcoil2663.work" "tcoil2663.gds")

cv_schematic = dbOpenCellViewByType("tcoil" "tcoil_master" "schematic")
CCSchangeParam( "tcoil" "tcoil_master" "schematic" "tcoil3_mmw" "pneo" "60" )
CCSchangeParam( "tcoil" "tcoil_master" "schematic" "tcoil3_mmw" "ctapLocation" "bot" )
CCSchangeParam( "tcoil" "tcoil_master" "schematic" "tcoil3_mmw" "od" "46u" )
CCSchangeParam( "tcoil" "tcoil_master" "schematic" "tcoil3_mmw" "w" "5.0u" )
CCSchangeParam( "tcoil" "tcoil_master" "schematic" "tcoil3_mmw" "neo" "12" )
CCSchangeParam( "tcoil" "tcoil_master" "schematic" "tcoil3_mmw" "nei" "5" )
lxGenFromSource( cv_schematic )
cv_layout = dbOpenCellViewByType("tcoil" "tcoil_master" "layout")
MovePinsToInstances( cv_schematic cv_layout )
StreamOutGDS("tcoil" "tcoil_master" "layout" "/autofs/fs1.ece/fs1.eecg.tcc/lizongh2/gf22x-1020b/EMX_work/tcoil_tcoil2664.work" "tcoil2664.gds")

cv_schematic = dbOpenCellViewByType("tcoil" "tcoil_master" "schematic")
CCSchangeParam( "tcoil" "tcoil_master" "schematic" "tcoil3_mmw" "pneo" "60" )
CCSchangeParam( "tcoil" "tcoil_master" "schematic" "tcoil3_mmw" "ctapLocation" "bot" )
CCSchangeParam( "tcoil" "tcoil_master" "schematic" "tcoil3_mmw" "od" "48u" )
CCSchangeParam( "tcoil" "tcoil_master" "schematic" "tcoil3_mmw" "w" "2.4u" )
CCSchangeParam( "tcoil" "tcoil_master" "schematic" "tcoil3_mmw" "neo" "4" )
CCSchangeParam( "tcoil" "tcoil_master" "schematic" "tcoil3_mmw" "nei" "5" )
lxGenFromSource( cv_schematic )
cv_layout = dbOpenCellViewByType("tcoil" "tcoil_master" "layout")
MovePinsToInstances( cv_schematic cv_layout )
StreamOutGDS("tcoil" "tcoil_master" "layout" "/autofs/fs1.ece/fs1.eecg.tcc/lizongh2/gf22x-1020b/EMX_work/tcoil_tcoil2665.work" "tcoil2665.gds")

cv_schematic = dbOpenCellViewByType("tcoil" "tcoil_master" "schematic")
CCSchangeParam( "tcoil" "tcoil_master" "schematic" "tcoil3_mmw" "pneo" "60" )
CCSchangeParam( "tcoil" "tcoil_master" "schematic" "tcoil3_mmw" "ctapLocation" "bot" )
CCSchangeParam( "tcoil" "tcoil_master" "schematic" "tcoil3_mmw" "od" "48u" )
CCSchangeParam( "tcoil" "tcoil_master" "schematic" "tcoil3_mmw" "w" "2.4u" )
CCSchangeParam( "tcoil" "tcoil_master" "schematic" "tcoil3_mmw" "neo" "6" )
CCSchangeParam( "tcoil" "tcoil_master" "schematic" "tcoil3_mmw" "nei" "5" )
lxGenFromSource( cv_schematic )
cv_layout = dbOpenCellViewByType("tcoil" "tcoil_master" "layout")
MovePinsToInstances( cv_schematic cv_layout )
StreamOutGDS("tcoil" "tcoil_master" "layout" "/autofs/fs1.ece/fs1.eecg.tcc/lizongh2/gf22x-1020b/EMX_work/tcoil_tcoil2666.work" "tcoil2666.gds")

cv_schematic = dbOpenCellViewByType("tcoil" "tcoil_master" "schematic")
CCSchangeParam( "tcoil" "tcoil_master" "schematic" "tcoil3_mmw" "pneo" "60" )
CCSchangeParam( "tcoil" "tcoil_master" "schematic" "tcoil3_mmw" "ctapLocation" "bot" )
CCSchangeParam( "tcoil" "tcoil_master" "schematic" "tcoil3_mmw" "od" "48u" )
CCSchangeParam( "tcoil" "tcoil_master" "schematic" "tcoil3_mmw" "w" "2.4u" )
CCSchangeParam( "tcoil" "tcoil_master" "schematic" "tcoil3_mmw" "neo" "8" )
CCSchangeParam( "tcoil" "tcoil_master" "schematic" "tcoil3_mmw" "nei" "5" )
lxGenFromSource( cv_schematic )
cv_layout = dbOpenCellViewByType("tcoil" "tcoil_master" "layout")
MovePinsToInstances( cv_schematic cv_layout )
StreamOutGDS("tcoil" "tcoil_master" "layout" "/autofs/fs1.ece/fs1.eecg.tcc/lizongh2/gf22x-1020b/EMX_work/tcoil_tcoil2667.work" "tcoil2667.gds")

cv_schematic = dbOpenCellViewByType("tcoil" "tcoil_master" "schematic")
CCSchangeParam( "tcoil" "tcoil_master" "schematic" "tcoil3_mmw" "pneo" "60" )
CCSchangeParam( "tcoil" "tcoil_master" "schematic" "tcoil3_mmw" "ctapLocation" "bot" )
CCSchangeParam( "tcoil" "tcoil_master" "schematic" "tcoil3_mmw" "od" "48u" )
CCSchangeParam( "tcoil" "tcoil_master" "schematic" "tcoil3_mmw" "w" "2.4u" )
CCSchangeParam( "tcoil" "tcoil_master" "schematic" "tcoil3_mmw" "neo" "10" )
CCSchangeParam( "tcoil" "tcoil_master" "schematic" "tcoil3_mmw" "nei" "5" )
lxGenFromSource( cv_schematic )
cv_layout = dbOpenCellViewByType("tcoil" "tcoil_master" "layout")
MovePinsToInstances( cv_schematic cv_layout )
StreamOutGDS("tcoil" "tcoil_master" "layout" "/autofs/fs1.ece/fs1.eecg.tcc/lizongh2/gf22x-1020b/EMX_work/tcoil_tcoil2668.work" "tcoil2668.gds")

cv_schematic = dbOpenCellViewByType("tcoil" "tcoil_master" "schematic")
CCSchangeParam( "tcoil" "tcoil_master" "schematic" "tcoil3_mmw" "pneo" "60" )
CCSchangeParam( "tcoil" "tcoil_master" "schematic" "tcoil3_mmw" "ctapLocation" "bot" )
CCSchangeParam( "tcoil" "tcoil_master" "schematic" "tcoil3_mmw" "od" "48u" )
CCSchangeParam( "tcoil" "tcoil_master" "schematic" "tcoil3_mmw" "w" "2.4u" )
CCSchangeParam( "tcoil" "tcoil_master" "schematic" "tcoil3_mmw" "neo" "12" )
CCSchangeParam( "tcoil" "tcoil_master" "schematic" "tcoil3_mmw" "nei" "5" )
lxGenFromSource( cv_schematic )
cv_layout = dbOpenCellViewByType("tcoil" "tcoil_master" "layout")
MovePinsToInstances( cv_schematic cv_layout )
StreamOutGDS("tcoil" "tcoil_master" "layout" "/autofs/fs1.ece/fs1.eecg.tcc/lizongh2/gf22x-1020b/EMX_work/tcoil_tcoil2669.work" "tcoil2669.gds")

cv_schematic = dbOpenCellViewByType("tcoil" "tcoil_master" "schematic")
CCSchangeParam( "tcoil" "tcoil_master" "schematic" "tcoil3_mmw" "pneo" "60" )
CCSchangeParam( "tcoil" "tcoil_master" "schematic" "tcoil3_mmw" "ctapLocation" "bot" )
CCSchangeParam( "tcoil" "tcoil_master" "schematic" "tcoil3_mmw" "od" "48u" )
CCSchangeParam( "tcoil" "tcoil_master" "schematic" "tcoil3_mmw" "w" "4.2u" )
CCSchangeParam( "tcoil" "tcoil_master" "schematic" "tcoil3_mmw" "neo" "4" )
CCSchangeParam( "tcoil" "tcoil_master" "schematic" "tcoil3_mmw" "nei" "5" )
lxGenFromSource( cv_schematic )
cv_layout = dbOpenCellViewByType("tcoil" "tcoil_master" "layout")
MovePinsToInstances( cv_schematic cv_layout )
StreamOutGDS("tcoil" "tcoil_master" "layout" "/autofs/fs1.ece/fs1.eecg.tcc/lizongh2/gf22x-1020b/EMX_work/tcoil_tcoil2670.work" "tcoil2670.gds")

cv_schematic = dbOpenCellViewByType("tcoil" "tcoil_master" "schematic")
CCSchangeParam( "tcoil" "tcoil_master" "schematic" "tcoil3_mmw" "pneo" "60" )
CCSchangeParam( "tcoil" "tcoil_master" "schematic" "tcoil3_mmw" "ctapLocation" "bot" )
CCSchangeParam( "tcoil" "tcoil_master" "schematic" "tcoil3_mmw" "od" "48u" )
CCSchangeParam( "tcoil" "tcoil_master" "schematic" "tcoil3_mmw" "w" "4.2u" )
CCSchangeParam( "tcoil" "tcoil_master" "schematic" "tcoil3_mmw" "neo" "6" )
CCSchangeParam( "tcoil" "tcoil_master" "schematic" "tcoil3_mmw" "nei" "5" )
lxGenFromSource( cv_schematic )
cv_layout = dbOpenCellViewByType("tcoil" "tcoil_master" "layout")
MovePinsToInstances( cv_schematic cv_layout )
StreamOutGDS("tcoil" "tcoil_master" "layout" "/autofs/fs1.ece/fs1.eecg.tcc/lizongh2/gf22x-1020b/EMX_work/tcoil_tcoil2671.work" "tcoil2671.gds")

cv_schematic = dbOpenCellViewByType("tcoil" "tcoil_master" "schematic")
CCSchangeParam( "tcoil" "tcoil_master" "schematic" "tcoil3_mmw" "pneo" "60" )
CCSchangeParam( "tcoil" "tcoil_master" "schematic" "tcoil3_mmw" "ctapLocation" "bot" )
CCSchangeParam( "tcoil" "tcoil_master" "schematic" "tcoil3_mmw" "od" "48u" )
CCSchangeParam( "tcoil" "tcoil_master" "schematic" "tcoil3_mmw" "w" "4.2u" )
CCSchangeParam( "tcoil" "tcoil_master" "schematic" "tcoil3_mmw" "neo" "8" )
CCSchangeParam( "tcoil" "tcoil_master" "schematic" "tcoil3_mmw" "nei" "5" )
lxGenFromSource( cv_schematic )
cv_layout = dbOpenCellViewByType("tcoil" "tcoil_master" "layout")
MovePinsToInstances( cv_schematic cv_layout )
StreamOutGDS("tcoil" "tcoil_master" "layout" "/autofs/fs1.ece/fs1.eecg.tcc/lizongh2/gf22x-1020b/EMX_work/tcoil_tcoil2672.work" "tcoil2672.gds")

cv_schematic = dbOpenCellViewByType("tcoil" "tcoil_master" "schematic")
CCSchangeParam( "tcoil" "tcoil_master" "schematic" "tcoil3_mmw" "pneo" "60" )
CCSchangeParam( "tcoil" "tcoil_master" "schematic" "tcoil3_mmw" "ctapLocation" "bot" )
CCSchangeParam( "tcoil" "tcoil_master" "schematic" "tcoil3_mmw" "od" "48u" )
CCSchangeParam( "tcoil" "tcoil_master" "schematic" "tcoil3_mmw" "w" "4.2u" )
CCSchangeParam( "tcoil" "tcoil_master" "schematic" "tcoil3_mmw" "neo" "10" )
CCSchangeParam( "tcoil" "tcoil_master" "schematic" "tcoil3_mmw" "nei" "5" )
lxGenFromSource( cv_schematic )
cv_layout = dbOpenCellViewByType("tcoil" "tcoil_master" "layout")
MovePinsToInstances( cv_schematic cv_layout )
StreamOutGDS("tcoil" "tcoil_master" "layout" "/autofs/fs1.ece/fs1.eecg.tcc/lizongh2/gf22x-1020b/EMX_work/tcoil_tcoil2673.work" "tcoil2673.gds")

cv_schematic = dbOpenCellViewByType("tcoil" "tcoil_master" "schematic")
CCSchangeParam( "tcoil" "tcoil_master" "schematic" "tcoil3_mmw" "pneo" "60" )
CCSchangeParam( "tcoil" "tcoil_master" "schematic" "tcoil3_mmw" "ctapLocation" "bot" )
CCSchangeParam( "tcoil" "tcoil_master" "schematic" "tcoil3_mmw" "od" "48u" )
CCSchangeParam( "tcoil" "tcoil_master" "schematic" "tcoil3_mmw" "w" "4.2u" )
CCSchangeParam( "tcoil" "tcoil_master" "schematic" "tcoil3_mmw" "neo" "12" )
CCSchangeParam( "tcoil" "tcoil_master" "schematic" "tcoil3_mmw" "nei" "5" )
lxGenFromSource( cv_schematic )
cv_layout = dbOpenCellViewByType("tcoil" "tcoil_master" "layout")
MovePinsToInstances( cv_schematic cv_layout )
StreamOutGDS("tcoil" "tcoil_master" "layout" "/autofs/fs1.ece/fs1.eecg.tcc/lizongh2/gf22x-1020b/EMX_work/tcoil_tcoil2674.work" "tcoil2674.gds")

cv_schematic = dbOpenCellViewByType("tcoil" "tcoil_master" "schematic")
CCSchangeParam( "tcoil" "tcoil_master" "schematic" "tcoil3_mmw" "pneo" "60" )
CCSchangeParam( "tcoil" "tcoil_master" "schematic" "tcoil3_mmw" "ctapLocation" "bot" )
CCSchangeParam( "tcoil" "tcoil_master" "schematic" "tcoil3_mmw" "od" "48u" )
CCSchangeParam( "tcoil" "tcoil_master" "schematic" "tcoil3_mmw" "w" "5.0u" )
CCSchangeParam( "tcoil" "tcoil_master" "schematic" "tcoil3_mmw" "neo" "4" )
CCSchangeParam( "tcoil" "tcoil_master" "schematic" "tcoil3_mmw" "nei" "5" )
lxGenFromSource( cv_schematic )
cv_layout = dbOpenCellViewByType("tcoil" "tcoil_master" "layout")
MovePinsToInstances( cv_schematic cv_layout )
StreamOutGDS("tcoil" "tcoil_master" "layout" "/autofs/fs1.ece/fs1.eecg.tcc/lizongh2/gf22x-1020b/EMX_work/tcoil_tcoil2675.work" "tcoil2675.gds")

cv_schematic = dbOpenCellViewByType("tcoil" "tcoil_master" "schematic")
CCSchangeParam( "tcoil" "tcoil_master" "schematic" "tcoil3_mmw" "pneo" "60" )
CCSchangeParam( "tcoil" "tcoil_master" "schematic" "tcoil3_mmw" "ctapLocation" "bot" )
CCSchangeParam( "tcoil" "tcoil_master" "schematic" "tcoil3_mmw" "od" "48u" )
CCSchangeParam( "tcoil" "tcoil_master" "schematic" "tcoil3_mmw" "w" "5.0u" )
CCSchangeParam( "tcoil" "tcoil_master" "schematic" "tcoil3_mmw" "neo" "6" )
CCSchangeParam( "tcoil" "tcoil_master" "schematic" "tcoil3_mmw" "nei" "5" )
lxGenFromSource( cv_schematic )
cv_layout = dbOpenCellViewByType("tcoil" "tcoil_master" "layout")
MovePinsToInstances( cv_schematic cv_layout )
StreamOutGDS("tcoil" "tcoil_master" "layout" "/autofs/fs1.ece/fs1.eecg.tcc/lizongh2/gf22x-1020b/EMX_work/tcoil_tcoil2676.work" "tcoil2676.gds")

cv_schematic = dbOpenCellViewByType("tcoil" "tcoil_master" "schematic")
CCSchangeParam( "tcoil" "tcoil_master" "schematic" "tcoil3_mmw" "pneo" "60" )
CCSchangeParam( "tcoil" "tcoil_master" "schematic" "tcoil3_mmw" "ctapLocation" "bot" )
CCSchangeParam( "tcoil" "tcoil_master" "schematic" "tcoil3_mmw" "od" "48u" )
CCSchangeParam( "tcoil" "tcoil_master" "schematic" "tcoil3_mmw" "w" "5.0u" )
CCSchangeParam( "tcoil" "tcoil_master" "schematic" "tcoil3_mmw" "neo" "8" )
CCSchangeParam( "tcoil" "tcoil_master" "schematic" "tcoil3_mmw" "nei" "5" )
lxGenFromSource( cv_schematic )
cv_layout = dbOpenCellViewByType("tcoil" "tcoil_master" "layout")
MovePinsToInstances( cv_schematic cv_layout )
StreamOutGDS("tcoil" "tcoil_master" "layout" "/autofs/fs1.ece/fs1.eecg.tcc/lizongh2/gf22x-1020b/EMX_work/tcoil_tcoil2677.work" "tcoil2677.gds")

cv_schematic = dbOpenCellViewByType("tcoil" "tcoil_master" "schematic")
CCSchangeParam( "tcoil" "tcoil_master" "schematic" "tcoil3_mmw" "pneo" "60" )
CCSchangeParam( "tcoil" "tcoil_master" "schematic" "tcoil3_mmw" "ctapLocation" "bot" )
CCSchangeParam( "tcoil" "tcoil_master" "schematic" "tcoil3_mmw" "od" "48u" )
CCSchangeParam( "tcoil" "tcoil_master" "schematic" "tcoil3_mmw" "w" "5.0u" )
CCSchangeParam( "tcoil" "tcoil_master" "schematic" "tcoil3_mmw" "neo" "10" )
CCSchangeParam( "tcoil" "tcoil_master" "schematic" "tcoil3_mmw" "nei" "5" )
lxGenFromSource( cv_schematic )
cv_layout = dbOpenCellViewByType("tcoil" "tcoil_master" "layout")
MovePinsToInstances( cv_schematic cv_layout )
StreamOutGDS("tcoil" "tcoil_master" "layout" "/autofs/fs1.ece/fs1.eecg.tcc/lizongh2/gf22x-1020b/EMX_work/tcoil_tcoil2678.work" "tcoil2678.gds")

cv_schematic = dbOpenCellViewByType("tcoil" "tcoil_master" "schematic")
CCSchangeParam( "tcoil" "tcoil_master" "schematic" "tcoil3_mmw" "pneo" "60" )
CCSchangeParam( "tcoil" "tcoil_master" "schematic" "tcoil3_mmw" "ctapLocation" "bot" )
CCSchangeParam( "tcoil" "tcoil_master" "schematic" "tcoil3_mmw" "od" "48u" )
CCSchangeParam( "tcoil" "tcoil_master" "schematic" "tcoil3_mmw" "w" "5.0u" )
CCSchangeParam( "tcoil" "tcoil_master" "schematic" "tcoil3_mmw" "neo" "12" )
CCSchangeParam( "tcoil" "tcoil_master" "schematic" "tcoil3_mmw" "nei" "5" )
lxGenFromSource( cv_schematic )
cv_layout = dbOpenCellViewByType("tcoil" "tcoil_master" "layout")
MovePinsToInstances( cv_schematic cv_layout )
StreamOutGDS("tcoil" "tcoil_master" "layout" "/autofs/fs1.ece/fs1.eecg.tcc/lizongh2/gf22x-1020b/EMX_work/tcoil_tcoil2679.work" "tcoil2679.gds")

cv_schematic = dbOpenCellViewByType("tcoil" "tcoil_master" "schematic")
CCSchangeParam( "tcoil" "tcoil_master" "schematic" "tcoil3_mmw" "pneo" "60" )
CCSchangeParam( "tcoil" "tcoil_master" "schematic" "tcoil3_mmw" "ctapLocation" "bot" )
CCSchangeParam( "tcoil" "tcoil_master" "schematic" "tcoil3_mmw" "od" "50u" )
CCSchangeParam( "tcoil" "tcoil_master" "schematic" "tcoil3_mmw" "w" "2.4u" )
CCSchangeParam( "tcoil" "tcoil_master" "schematic" "tcoil3_mmw" "neo" "4" )
CCSchangeParam( "tcoil" "tcoil_master" "schematic" "tcoil3_mmw" "nei" "5" )
lxGenFromSource( cv_schematic )
cv_layout = dbOpenCellViewByType("tcoil" "tcoil_master" "layout")
MovePinsToInstances( cv_schematic cv_layout )
StreamOutGDS("tcoil" "tcoil_master" "layout" "/autofs/fs1.ece/fs1.eecg.tcc/lizongh2/gf22x-1020b/EMX_work/tcoil_tcoil2680.work" "tcoil2680.gds")

cv_schematic = dbOpenCellViewByType("tcoil" "tcoil_master" "schematic")
CCSchangeParam( "tcoil" "tcoil_master" "schematic" "tcoil3_mmw" "pneo" "60" )
CCSchangeParam( "tcoil" "tcoil_master" "schematic" "tcoil3_mmw" "ctapLocation" "bot" )
CCSchangeParam( "tcoil" "tcoil_master" "schematic" "tcoil3_mmw" "od" "50u" )
CCSchangeParam( "tcoil" "tcoil_master" "schematic" "tcoil3_mmw" "w" "2.4u" )
CCSchangeParam( "tcoil" "tcoil_master" "schematic" "tcoil3_mmw" "neo" "6" )
CCSchangeParam( "tcoil" "tcoil_master" "schematic" "tcoil3_mmw" "nei" "5" )
lxGenFromSource( cv_schematic )
cv_layout = dbOpenCellViewByType("tcoil" "tcoil_master" "layout")
MovePinsToInstances( cv_schematic cv_layout )
StreamOutGDS("tcoil" "tcoil_master" "layout" "/autofs/fs1.ece/fs1.eecg.tcc/lizongh2/gf22x-1020b/EMX_work/tcoil_tcoil2681.work" "tcoil2681.gds")

cv_schematic = dbOpenCellViewByType("tcoil" "tcoil_master" "schematic")
CCSchangeParam( "tcoil" "tcoil_master" "schematic" "tcoil3_mmw" "pneo" "60" )
CCSchangeParam( "tcoil" "tcoil_master" "schematic" "tcoil3_mmw" "ctapLocation" "bot" )
CCSchangeParam( "tcoil" "tcoil_master" "schematic" "tcoil3_mmw" "od" "50u" )
CCSchangeParam( "tcoil" "tcoil_master" "schematic" "tcoil3_mmw" "w" "2.4u" )
CCSchangeParam( "tcoil" "tcoil_master" "schematic" "tcoil3_mmw" "neo" "8" )
CCSchangeParam( "tcoil" "tcoil_master" "schematic" "tcoil3_mmw" "nei" "5" )
lxGenFromSource( cv_schematic )
cv_layout = dbOpenCellViewByType("tcoil" "tcoil_master" "layout")
MovePinsToInstances( cv_schematic cv_layout )
StreamOutGDS("tcoil" "tcoil_master" "layout" "/autofs/fs1.ece/fs1.eecg.tcc/lizongh2/gf22x-1020b/EMX_work/tcoil_tcoil2682.work" "tcoil2682.gds")

cv_schematic = dbOpenCellViewByType("tcoil" "tcoil_master" "schematic")
CCSchangeParam( "tcoil" "tcoil_master" "schematic" "tcoil3_mmw" "pneo" "60" )
CCSchangeParam( "tcoil" "tcoil_master" "schematic" "tcoil3_mmw" "ctapLocation" "bot" )
CCSchangeParam( "tcoil" "tcoil_master" "schematic" "tcoil3_mmw" "od" "50u" )
CCSchangeParam( "tcoil" "tcoil_master" "schematic" "tcoil3_mmw" "w" "2.4u" )
CCSchangeParam( "tcoil" "tcoil_master" "schematic" "tcoil3_mmw" "neo" "10" )
CCSchangeParam( "tcoil" "tcoil_master" "schematic" "tcoil3_mmw" "nei" "5" )
lxGenFromSource( cv_schematic )
cv_layout = dbOpenCellViewByType("tcoil" "tcoil_master" "layout")
MovePinsToInstances( cv_schematic cv_layout )
StreamOutGDS("tcoil" "tcoil_master" "layout" "/autofs/fs1.ece/fs1.eecg.tcc/lizongh2/gf22x-1020b/EMX_work/tcoil_tcoil2683.work" "tcoil2683.gds")

cv_schematic = dbOpenCellViewByType("tcoil" "tcoil_master" "schematic")
CCSchangeParam( "tcoil" "tcoil_master" "schematic" "tcoil3_mmw" "pneo" "60" )
CCSchangeParam( "tcoil" "tcoil_master" "schematic" "tcoil3_mmw" "ctapLocation" "bot" )
CCSchangeParam( "tcoil" "tcoil_master" "schematic" "tcoil3_mmw" "od" "50u" )
CCSchangeParam( "tcoil" "tcoil_master" "schematic" "tcoil3_mmw" "w" "2.4u" )
CCSchangeParam( "tcoil" "tcoil_master" "schematic" "tcoil3_mmw" "neo" "12" )
CCSchangeParam( "tcoil" "tcoil_master" "schematic" "tcoil3_mmw" "nei" "5" )
lxGenFromSource( cv_schematic )
cv_layout = dbOpenCellViewByType("tcoil" "tcoil_master" "layout")
MovePinsToInstances( cv_schematic cv_layout )
StreamOutGDS("tcoil" "tcoil_master" "layout" "/autofs/fs1.ece/fs1.eecg.tcc/lizongh2/gf22x-1020b/EMX_work/tcoil_tcoil2684.work" "tcoil2684.gds")

cv_schematic = dbOpenCellViewByType("tcoil" "tcoil_master" "schematic")
CCSchangeParam( "tcoil" "tcoil_master" "schematic" "tcoil3_mmw" "pneo" "60" )
CCSchangeParam( "tcoil" "tcoil_master" "schematic" "tcoil3_mmw" "ctapLocation" "bot" )
CCSchangeParam( "tcoil" "tcoil_master" "schematic" "tcoil3_mmw" "od" "50u" )
CCSchangeParam( "tcoil" "tcoil_master" "schematic" "tcoil3_mmw" "w" "4.2u" )
CCSchangeParam( "tcoil" "tcoil_master" "schematic" "tcoil3_mmw" "neo" "4" )
CCSchangeParam( "tcoil" "tcoil_master" "schematic" "tcoil3_mmw" "nei" "5" )
lxGenFromSource( cv_schematic )
cv_layout = dbOpenCellViewByType("tcoil" "tcoil_master" "layout")
MovePinsToInstances( cv_schematic cv_layout )
StreamOutGDS("tcoil" "tcoil_master" "layout" "/autofs/fs1.ece/fs1.eecg.tcc/lizongh2/gf22x-1020b/EMX_work/tcoil_tcoil2685.work" "tcoil2685.gds")

cv_schematic = dbOpenCellViewByType("tcoil" "tcoil_master" "schematic")
CCSchangeParam( "tcoil" "tcoil_master" "schematic" "tcoil3_mmw" "pneo" "60" )
CCSchangeParam( "tcoil" "tcoil_master" "schematic" "tcoil3_mmw" "ctapLocation" "bot" )
CCSchangeParam( "tcoil" "tcoil_master" "schematic" "tcoil3_mmw" "od" "50u" )
CCSchangeParam( "tcoil" "tcoil_master" "schematic" "tcoil3_mmw" "w" "4.2u" )
CCSchangeParam( "tcoil" "tcoil_master" "schematic" "tcoil3_mmw" "neo" "6" )
CCSchangeParam( "tcoil" "tcoil_master" "schematic" "tcoil3_mmw" "nei" "5" )
lxGenFromSource( cv_schematic )
cv_layout = dbOpenCellViewByType("tcoil" "tcoil_master" "layout")
MovePinsToInstances( cv_schematic cv_layout )
StreamOutGDS("tcoil" "tcoil_master" "layout" "/autofs/fs1.ece/fs1.eecg.tcc/lizongh2/gf22x-1020b/EMX_work/tcoil_tcoil2686.work" "tcoil2686.gds")

cv_schematic = dbOpenCellViewByType("tcoil" "tcoil_master" "schematic")
CCSchangeParam( "tcoil" "tcoil_master" "schematic" "tcoil3_mmw" "pneo" "60" )
CCSchangeParam( "tcoil" "tcoil_master" "schematic" "tcoil3_mmw" "ctapLocation" "bot" )
CCSchangeParam( "tcoil" "tcoil_master" "schematic" "tcoil3_mmw" "od" "50u" )
CCSchangeParam( "tcoil" "tcoil_master" "schematic" "tcoil3_mmw" "w" "4.2u" )
CCSchangeParam( "tcoil" "tcoil_master" "schematic" "tcoil3_mmw" "neo" "8" )
CCSchangeParam( "tcoil" "tcoil_master" "schematic" "tcoil3_mmw" "nei" "5" )
lxGenFromSource( cv_schematic )
cv_layout = dbOpenCellViewByType("tcoil" "tcoil_master" "layout")
MovePinsToInstances( cv_schematic cv_layout )
StreamOutGDS("tcoil" "tcoil_master" "layout" "/autofs/fs1.ece/fs1.eecg.tcc/lizongh2/gf22x-1020b/EMX_work/tcoil_tcoil2687.work" "tcoil2687.gds")

cv_schematic = dbOpenCellViewByType("tcoil" "tcoil_master" "schematic")
CCSchangeParam( "tcoil" "tcoil_master" "schematic" "tcoil3_mmw" "pneo" "60" )
CCSchangeParam( "tcoil" "tcoil_master" "schematic" "tcoil3_mmw" "ctapLocation" "bot" )
CCSchangeParam( "tcoil" "tcoil_master" "schematic" "tcoil3_mmw" "od" "50u" )
CCSchangeParam( "tcoil" "tcoil_master" "schematic" "tcoil3_mmw" "w" "4.2u" )
CCSchangeParam( "tcoil" "tcoil_master" "schematic" "tcoil3_mmw" "neo" "10" )
CCSchangeParam( "tcoil" "tcoil_master" "schematic" "tcoil3_mmw" "nei" "5" )
lxGenFromSource( cv_schematic )
cv_layout = dbOpenCellViewByType("tcoil" "tcoil_master" "layout")
MovePinsToInstances( cv_schematic cv_layout )
StreamOutGDS("tcoil" "tcoil_master" "layout" "/autofs/fs1.ece/fs1.eecg.tcc/lizongh2/gf22x-1020b/EMX_work/tcoil_tcoil2688.work" "tcoil2688.gds")

cv_schematic = dbOpenCellViewByType("tcoil" "tcoil_master" "schematic")
CCSchangeParam( "tcoil" "tcoil_master" "schematic" "tcoil3_mmw" "pneo" "60" )
CCSchangeParam( "tcoil" "tcoil_master" "schematic" "tcoil3_mmw" "ctapLocation" "bot" )
CCSchangeParam( "tcoil" "tcoil_master" "schematic" "tcoil3_mmw" "od" "50u" )
CCSchangeParam( "tcoil" "tcoil_master" "schematic" "tcoil3_mmw" "w" "4.2u" )
CCSchangeParam( "tcoil" "tcoil_master" "schematic" "tcoil3_mmw" "neo" "12" )
CCSchangeParam( "tcoil" "tcoil_master" "schematic" "tcoil3_mmw" "nei" "5" )
lxGenFromSource( cv_schematic )
cv_layout = dbOpenCellViewByType("tcoil" "tcoil_master" "layout")
MovePinsToInstances( cv_schematic cv_layout )
StreamOutGDS("tcoil" "tcoil_master" "layout" "/autofs/fs1.ece/fs1.eecg.tcc/lizongh2/gf22x-1020b/EMX_work/tcoil_tcoil2689.work" "tcoil2689.gds")

cv_schematic = dbOpenCellViewByType("tcoil" "tcoil_master" "schematic")
CCSchangeParam( "tcoil" "tcoil_master" "schematic" "tcoil3_mmw" "pneo" "60" )
CCSchangeParam( "tcoil" "tcoil_master" "schematic" "tcoil3_mmw" "ctapLocation" "bot" )
CCSchangeParam( "tcoil" "tcoil_master" "schematic" "tcoil3_mmw" "od" "50u" )
CCSchangeParam( "tcoil" "tcoil_master" "schematic" "tcoil3_mmw" "w" "5.0u" )
CCSchangeParam( "tcoil" "tcoil_master" "schematic" "tcoil3_mmw" "neo" "4" )
CCSchangeParam( "tcoil" "tcoil_master" "schematic" "tcoil3_mmw" "nei" "5" )
lxGenFromSource( cv_schematic )
cv_layout = dbOpenCellViewByType("tcoil" "tcoil_master" "layout")
MovePinsToInstances( cv_schematic cv_layout )
StreamOutGDS("tcoil" "tcoil_master" "layout" "/autofs/fs1.ece/fs1.eecg.tcc/lizongh2/gf22x-1020b/EMX_work/tcoil_tcoil2690.work" "tcoil2690.gds")

cv_schematic = dbOpenCellViewByType("tcoil" "tcoil_master" "schematic")
CCSchangeParam( "tcoil" "tcoil_master" "schematic" "tcoil3_mmw" "pneo" "60" )
CCSchangeParam( "tcoil" "tcoil_master" "schematic" "tcoil3_mmw" "ctapLocation" "bot" )
CCSchangeParam( "tcoil" "tcoil_master" "schematic" "tcoil3_mmw" "od" "50u" )
CCSchangeParam( "tcoil" "tcoil_master" "schematic" "tcoil3_mmw" "w" "5.0u" )
CCSchangeParam( "tcoil" "tcoil_master" "schematic" "tcoil3_mmw" "neo" "6" )
CCSchangeParam( "tcoil" "tcoil_master" "schematic" "tcoil3_mmw" "nei" "5" )
lxGenFromSource( cv_schematic )
cv_layout = dbOpenCellViewByType("tcoil" "tcoil_master" "layout")
MovePinsToInstances( cv_schematic cv_layout )
StreamOutGDS("tcoil" "tcoil_master" "layout" "/autofs/fs1.ece/fs1.eecg.tcc/lizongh2/gf22x-1020b/EMX_work/tcoil_tcoil2691.work" "tcoil2691.gds")

cv_schematic = dbOpenCellViewByType("tcoil" "tcoil_master" "schematic")
CCSchangeParam( "tcoil" "tcoil_master" "schematic" "tcoil3_mmw" "pneo" "60" )
CCSchangeParam( "tcoil" "tcoil_master" "schematic" "tcoil3_mmw" "ctapLocation" "bot" )
CCSchangeParam( "tcoil" "tcoil_master" "schematic" "tcoil3_mmw" "od" "50u" )
CCSchangeParam( "tcoil" "tcoil_master" "schematic" "tcoil3_mmw" "w" "5.0u" )
CCSchangeParam( "tcoil" "tcoil_master" "schematic" "tcoil3_mmw" "neo" "8" )
CCSchangeParam( "tcoil" "tcoil_master" "schematic" "tcoil3_mmw" "nei" "5" )
lxGenFromSource( cv_schematic )
cv_layout = dbOpenCellViewByType("tcoil" "tcoil_master" "layout")
MovePinsToInstances( cv_schematic cv_layout )
StreamOutGDS("tcoil" "tcoil_master" "layout" "/autofs/fs1.ece/fs1.eecg.tcc/lizongh2/gf22x-1020b/EMX_work/tcoil_tcoil2692.work" "tcoil2692.gds")

cv_schematic = dbOpenCellViewByType("tcoil" "tcoil_master" "schematic")
CCSchangeParam( "tcoil" "tcoil_master" "schematic" "tcoil3_mmw" "pneo" "60" )
CCSchangeParam( "tcoil" "tcoil_master" "schematic" "tcoil3_mmw" "ctapLocation" "bot" )
CCSchangeParam( "tcoil" "tcoil_master" "schematic" "tcoil3_mmw" "od" "50u" )
CCSchangeParam( "tcoil" "tcoil_master" "schematic" "tcoil3_mmw" "w" "5.0u" )
CCSchangeParam( "tcoil" "tcoil_master" "schematic" "tcoil3_mmw" "neo" "10" )
CCSchangeParam( "tcoil" "tcoil_master" "schematic" "tcoil3_mmw" "nei" "5" )
lxGenFromSource( cv_schematic )
cv_layout = dbOpenCellViewByType("tcoil" "tcoil_master" "layout")
MovePinsToInstances( cv_schematic cv_layout )
StreamOutGDS("tcoil" "tcoil_master" "layout" "/autofs/fs1.ece/fs1.eecg.tcc/lizongh2/gf22x-1020b/EMX_work/tcoil_tcoil2693.work" "tcoil2693.gds")

cv_schematic = dbOpenCellViewByType("tcoil" "tcoil_master" "schematic")
CCSchangeParam( "tcoil" "tcoil_master" "schematic" "tcoil3_mmw" "pneo" "60" )
CCSchangeParam( "tcoil" "tcoil_master" "schematic" "tcoil3_mmw" "ctapLocation" "bot" )
CCSchangeParam( "tcoil" "tcoil_master" "schematic" "tcoil3_mmw" "od" "50u" )
CCSchangeParam( "tcoil" "tcoil_master" "schematic" "tcoil3_mmw" "w" "5.0u" )
CCSchangeParam( "tcoil" "tcoil_master" "schematic" "tcoil3_mmw" "neo" "12" )
CCSchangeParam( "tcoil" "tcoil_master" "schematic" "tcoil3_mmw" "nei" "5" )
lxGenFromSource( cv_schematic )
cv_layout = dbOpenCellViewByType("tcoil" "tcoil_master" "layout")
MovePinsToInstances( cv_schematic cv_layout )
StreamOutGDS("tcoil" "tcoil_master" "layout" "/autofs/fs1.ece/fs1.eecg.tcc/lizongh2/gf22x-1020b/EMX_work/tcoil_tcoil2694.work" "tcoil2694.gds")

cv_schematic = dbOpenCellViewByType("tcoil" "tcoil_master" "schematic")
CCSchangeParam( "tcoil" "tcoil_master" "schematic" "tcoil3_mmw" "pneo" "60" )
CCSchangeParam( "tcoil" "tcoil_master" "schematic" "tcoil3_mmw" "ctapLocation" "bot" )
CCSchangeParam( "tcoil" "tcoil_master" "schematic" "tcoil3_mmw" "od" "52u" )
CCSchangeParam( "tcoil" "tcoil_master" "schematic" "tcoil3_mmw" "w" "2.4u" )
CCSchangeParam( "tcoil" "tcoil_master" "schematic" "tcoil3_mmw" "neo" "4" )
CCSchangeParam( "tcoil" "tcoil_master" "schematic" "tcoil3_mmw" "nei" "5" )
lxGenFromSource( cv_schematic )
cv_layout = dbOpenCellViewByType("tcoil" "tcoil_master" "layout")
MovePinsToInstances( cv_schematic cv_layout )
StreamOutGDS("tcoil" "tcoil_master" "layout" "/autofs/fs1.ece/fs1.eecg.tcc/lizongh2/gf22x-1020b/EMX_work/tcoil_tcoil2695.work" "tcoil2695.gds")

cv_schematic = dbOpenCellViewByType("tcoil" "tcoil_master" "schematic")
CCSchangeParam( "tcoil" "tcoil_master" "schematic" "tcoil3_mmw" "pneo" "60" )
CCSchangeParam( "tcoil" "tcoil_master" "schematic" "tcoil3_mmw" "ctapLocation" "bot" )
CCSchangeParam( "tcoil" "tcoil_master" "schematic" "tcoil3_mmw" "od" "52u" )
CCSchangeParam( "tcoil" "tcoil_master" "schematic" "tcoil3_mmw" "w" "2.4u" )
CCSchangeParam( "tcoil" "tcoil_master" "schematic" "tcoil3_mmw" "neo" "6" )
CCSchangeParam( "tcoil" "tcoil_master" "schematic" "tcoil3_mmw" "nei" "5" )
lxGenFromSource( cv_schematic )
cv_layout = dbOpenCellViewByType("tcoil" "tcoil_master" "layout")
MovePinsToInstances( cv_schematic cv_layout )
StreamOutGDS("tcoil" "tcoil_master" "layout" "/autofs/fs1.ece/fs1.eecg.tcc/lizongh2/gf22x-1020b/EMX_work/tcoil_tcoil2696.work" "tcoil2696.gds")

cv_schematic = dbOpenCellViewByType("tcoil" "tcoil_master" "schematic")
CCSchangeParam( "tcoil" "tcoil_master" "schematic" "tcoil3_mmw" "pneo" "60" )
CCSchangeParam( "tcoil" "tcoil_master" "schematic" "tcoil3_mmw" "ctapLocation" "bot" )
CCSchangeParam( "tcoil" "tcoil_master" "schematic" "tcoil3_mmw" "od" "52u" )
CCSchangeParam( "tcoil" "tcoil_master" "schematic" "tcoil3_mmw" "w" "2.4u" )
CCSchangeParam( "tcoil" "tcoil_master" "schematic" "tcoil3_mmw" "neo" "8" )
CCSchangeParam( "tcoil" "tcoil_master" "schematic" "tcoil3_mmw" "nei" "5" )
lxGenFromSource( cv_schematic )
cv_layout = dbOpenCellViewByType("tcoil" "tcoil_master" "layout")
MovePinsToInstances( cv_schematic cv_layout )
StreamOutGDS("tcoil" "tcoil_master" "layout" "/autofs/fs1.ece/fs1.eecg.tcc/lizongh2/gf22x-1020b/EMX_work/tcoil_tcoil2697.work" "tcoil2697.gds")

cv_schematic = dbOpenCellViewByType("tcoil" "tcoil_master" "schematic")
CCSchangeParam( "tcoil" "tcoil_master" "schematic" "tcoil3_mmw" "pneo" "60" )
CCSchangeParam( "tcoil" "tcoil_master" "schematic" "tcoil3_mmw" "ctapLocation" "bot" )
CCSchangeParam( "tcoil" "tcoil_master" "schematic" "tcoil3_mmw" "od" "52u" )
CCSchangeParam( "tcoil" "tcoil_master" "schematic" "tcoil3_mmw" "w" "2.4u" )
CCSchangeParam( "tcoil" "tcoil_master" "schematic" "tcoil3_mmw" "neo" "10" )
CCSchangeParam( "tcoil" "tcoil_master" "schematic" "tcoil3_mmw" "nei" "5" )
lxGenFromSource( cv_schematic )
cv_layout = dbOpenCellViewByType("tcoil" "tcoil_master" "layout")
MovePinsToInstances( cv_schematic cv_layout )
StreamOutGDS("tcoil" "tcoil_master" "layout" "/autofs/fs1.ece/fs1.eecg.tcc/lizongh2/gf22x-1020b/EMX_work/tcoil_tcoil2698.work" "tcoil2698.gds")

cv_schematic = dbOpenCellViewByType("tcoil" "tcoil_master" "schematic")
CCSchangeParam( "tcoil" "tcoil_master" "schematic" "tcoil3_mmw" "pneo" "60" )
CCSchangeParam( "tcoil" "tcoil_master" "schematic" "tcoil3_mmw" "ctapLocation" "bot" )
CCSchangeParam( "tcoil" "tcoil_master" "schematic" "tcoil3_mmw" "od" "52u" )
CCSchangeParam( "tcoil" "tcoil_master" "schematic" "tcoil3_mmw" "w" "2.4u" )
CCSchangeParam( "tcoil" "tcoil_master" "schematic" "tcoil3_mmw" "neo" "12" )
CCSchangeParam( "tcoil" "tcoil_master" "schematic" "tcoil3_mmw" "nei" "5" )
lxGenFromSource( cv_schematic )
cv_layout = dbOpenCellViewByType("tcoil" "tcoil_master" "layout")
MovePinsToInstances( cv_schematic cv_layout )
StreamOutGDS("tcoil" "tcoil_master" "layout" "/autofs/fs1.ece/fs1.eecg.tcc/lizongh2/gf22x-1020b/EMX_work/tcoil_tcoil2699.work" "tcoil2699.gds")

cv_schematic = dbOpenCellViewByType("tcoil" "tcoil_master" "schematic")
CCSchangeParam( "tcoil" "tcoil_master" "schematic" "tcoil3_mmw" "pneo" "60" )
CCSchangeParam( "tcoil" "tcoil_master" "schematic" "tcoil3_mmw" "ctapLocation" "bot" )
CCSchangeParam( "tcoil" "tcoil_master" "schematic" "tcoil3_mmw" "od" "52u" )
CCSchangeParam( "tcoil" "tcoil_master" "schematic" "tcoil3_mmw" "w" "4.2u" )
CCSchangeParam( "tcoil" "tcoil_master" "schematic" "tcoil3_mmw" "neo" "4" )
CCSchangeParam( "tcoil" "tcoil_master" "schematic" "tcoil3_mmw" "nei" "5" )
lxGenFromSource( cv_schematic )
cv_layout = dbOpenCellViewByType("tcoil" "tcoil_master" "layout")
MovePinsToInstances( cv_schematic cv_layout )
StreamOutGDS("tcoil" "tcoil_master" "layout" "/autofs/fs1.ece/fs1.eecg.tcc/lizongh2/gf22x-1020b/EMX_work/tcoil_tcoil2700.work" "tcoil2700.gds")

cv_schematic = dbOpenCellViewByType("tcoil" "tcoil_master" "schematic")
CCSchangeParam( "tcoil" "tcoil_master" "schematic" "tcoil3_mmw" "pneo" "60" )
CCSchangeParam( "tcoil" "tcoil_master" "schematic" "tcoil3_mmw" "ctapLocation" "bot" )
CCSchangeParam( "tcoil" "tcoil_master" "schematic" "tcoil3_mmw" "od" "52u" )
CCSchangeParam( "tcoil" "tcoil_master" "schematic" "tcoil3_mmw" "w" "4.2u" )
CCSchangeParam( "tcoil" "tcoil_master" "schematic" "tcoil3_mmw" "neo" "6" )
CCSchangeParam( "tcoil" "tcoil_master" "schematic" "tcoil3_mmw" "nei" "5" )
lxGenFromSource( cv_schematic )
cv_layout = dbOpenCellViewByType("tcoil" "tcoil_master" "layout")
MovePinsToInstances( cv_schematic cv_layout )
StreamOutGDS("tcoil" "tcoil_master" "layout" "/autofs/fs1.ece/fs1.eecg.tcc/lizongh2/gf22x-1020b/EMX_work/tcoil_tcoil2701.work" "tcoil2701.gds")

cv_schematic = dbOpenCellViewByType("tcoil" "tcoil_master" "schematic")
CCSchangeParam( "tcoil" "tcoil_master" "schematic" "tcoil3_mmw" "pneo" "60" )
CCSchangeParam( "tcoil" "tcoil_master" "schematic" "tcoil3_mmw" "ctapLocation" "bot" )
CCSchangeParam( "tcoil" "tcoil_master" "schematic" "tcoil3_mmw" "od" "52u" )
CCSchangeParam( "tcoil" "tcoil_master" "schematic" "tcoil3_mmw" "w" "4.2u" )
CCSchangeParam( "tcoil" "tcoil_master" "schematic" "tcoil3_mmw" "neo" "8" )
CCSchangeParam( "tcoil" "tcoil_master" "schematic" "tcoil3_mmw" "nei" "5" )
lxGenFromSource( cv_schematic )
cv_layout = dbOpenCellViewByType("tcoil" "tcoil_master" "layout")
MovePinsToInstances( cv_schematic cv_layout )
StreamOutGDS("tcoil" "tcoil_master" "layout" "/autofs/fs1.ece/fs1.eecg.tcc/lizongh2/gf22x-1020b/EMX_work/tcoil_tcoil2702.work" "tcoil2702.gds")

cv_schematic = dbOpenCellViewByType("tcoil" "tcoil_master" "schematic")
CCSchangeParam( "tcoil" "tcoil_master" "schematic" "tcoil3_mmw" "pneo" "60" )
CCSchangeParam( "tcoil" "tcoil_master" "schematic" "tcoil3_mmw" "ctapLocation" "bot" )
CCSchangeParam( "tcoil" "tcoil_master" "schematic" "tcoil3_mmw" "od" "52u" )
CCSchangeParam( "tcoil" "tcoil_master" "schematic" "tcoil3_mmw" "w" "4.2u" )
CCSchangeParam( "tcoil" "tcoil_master" "schematic" "tcoil3_mmw" "neo" "10" )
CCSchangeParam( "tcoil" "tcoil_master" "schematic" "tcoil3_mmw" "nei" "5" )
lxGenFromSource( cv_schematic )
cv_layout = dbOpenCellViewByType("tcoil" "tcoil_master" "layout")
MovePinsToInstances( cv_schematic cv_layout )
StreamOutGDS("tcoil" "tcoil_master" "layout" "/autofs/fs1.ece/fs1.eecg.tcc/lizongh2/gf22x-1020b/EMX_work/tcoil_tcoil2703.work" "tcoil2703.gds")

cv_schematic = dbOpenCellViewByType("tcoil" "tcoil_master" "schematic")
CCSchangeParam( "tcoil" "tcoil_master" "schematic" "tcoil3_mmw" "pneo" "60" )
CCSchangeParam( "tcoil" "tcoil_master" "schematic" "tcoil3_mmw" "ctapLocation" "bot" )
CCSchangeParam( "tcoil" "tcoil_master" "schematic" "tcoil3_mmw" "od" "52u" )
CCSchangeParam( "tcoil" "tcoil_master" "schematic" "tcoil3_mmw" "w" "4.2u" )
CCSchangeParam( "tcoil" "tcoil_master" "schematic" "tcoil3_mmw" "neo" "12" )
CCSchangeParam( "tcoil" "tcoil_master" "schematic" "tcoil3_mmw" "nei" "5" )
lxGenFromSource( cv_schematic )
cv_layout = dbOpenCellViewByType("tcoil" "tcoil_master" "layout")
MovePinsToInstances( cv_schematic cv_layout )
StreamOutGDS("tcoil" "tcoil_master" "layout" "/autofs/fs1.ece/fs1.eecg.tcc/lizongh2/gf22x-1020b/EMX_work/tcoil_tcoil2704.work" "tcoil2704.gds")

cv_schematic = dbOpenCellViewByType("tcoil" "tcoil_master" "schematic")
CCSchangeParam( "tcoil" "tcoil_master" "schematic" "tcoil3_mmw" "pneo" "60" )
CCSchangeParam( "tcoil" "tcoil_master" "schematic" "tcoil3_mmw" "ctapLocation" "bot" )
CCSchangeParam( "tcoil" "tcoil_master" "schematic" "tcoil3_mmw" "od" "52u" )
CCSchangeParam( "tcoil" "tcoil_master" "schematic" "tcoil3_mmw" "w" "5.0u" )
CCSchangeParam( "tcoil" "tcoil_master" "schematic" "tcoil3_mmw" "neo" "4" )
CCSchangeParam( "tcoil" "tcoil_master" "schematic" "tcoil3_mmw" "nei" "5" )
lxGenFromSource( cv_schematic )
cv_layout = dbOpenCellViewByType("tcoil" "tcoil_master" "layout")
MovePinsToInstances( cv_schematic cv_layout )
StreamOutGDS("tcoil" "tcoil_master" "layout" "/autofs/fs1.ece/fs1.eecg.tcc/lizongh2/gf22x-1020b/EMX_work/tcoil_tcoil2705.work" "tcoil2705.gds")

cv_schematic = dbOpenCellViewByType("tcoil" "tcoil_master" "schematic")
CCSchangeParam( "tcoil" "tcoil_master" "schematic" "tcoil3_mmw" "pneo" "60" )
CCSchangeParam( "tcoil" "tcoil_master" "schematic" "tcoil3_mmw" "ctapLocation" "bot" )
CCSchangeParam( "tcoil" "tcoil_master" "schematic" "tcoil3_mmw" "od" "52u" )
CCSchangeParam( "tcoil" "tcoil_master" "schematic" "tcoil3_mmw" "w" "5.0u" )
CCSchangeParam( "tcoil" "tcoil_master" "schematic" "tcoil3_mmw" "neo" "6" )
CCSchangeParam( "tcoil" "tcoil_master" "schematic" "tcoil3_mmw" "nei" "5" )
lxGenFromSource( cv_schematic )
cv_layout = dbOpenCellViewByType("tcoil" "tcoil_master" "layout")
MovePinsToInstances( cv_schematic cv_layout )
StreamOutGDS("tcoil" "tcoil_master" "layout" "/autofs/fs1.ece/fs1.eecg.tcc/lizongh2/gf22x-1020b/EMX_work/tcoil_tcoil2706.work" "tcoil2706.gds")

cv_schematic = dbOpenCellViewByType("tcoil" "tcoil_master" "schematic")
CCSchangeParam( "tcoil" "tcoil_master" "schematic" "tcoil3_mmw" "pneo" "60" )
CCSchangeParam( "tcoil" "tcoil_master" "schematic" "tcoil3_mmw" "ctapLocation" "bot" )
CCSchangeParam( "tcoil" "tcoil_master" "schematic" "tcoil3_mmw" "od" "52u" )
CCSchangeParam( "tcoil" "tcoil_master" "schematic" "tcoil3_mmw" "w" "5.0u" )
CCSchangeParam( "tcoil" "tcoil_master" "schematic" "tcoil3_mmw" "neo" "8" )
CCSchangeParam( "tcoil" "tcoil_master" "schematic" "tcoil3_mmw" "nei" "5" )
lxGenFromSource( cv_schematic )
cv_layout = dbOpenCellViewByType("tcoil" "tcoil_master" "layout")
MovePinsToInstances( cv_schematic cv_layout )
StreamOutGDS("tcoil" "tcoil_master" "layout" "/autofs/fs1.ece/fs1.eecg.tcc/lizongh2/gf22x-1020b/EMX_work/tcoil_tcoil2707.work" "tcoil2707.gds")

cv_schematic = dbOpenCellViewByType("tcoil" "tcoil_master" "schematic")
CCSchangeParam( "tcoil" "tcoil_master" "schematic" "tcoil3_mmw" "pneo" "60" )
CCSchangeParam( "tcoil" "tcoil_master" "schematic" "tcoil3_mmw" "ctapLocation" "bot" )
CCSchangeParam( "tcoil" "tcoil_master" "schematic" "tcoil3_mmw" "od" "52u" )
CCSchangeParam( "tcoil" "tcoil_master" "schematic" "tcoil3_mmw" "w" "5.0u" )
CCSchangeParam( "tcoil" "tcoil_master" "schematic" "tcoil3_mmw" "neo" "10" )
CCSchangeParam( "tcoil" "tcoil_master" "schematic" "tcoil3_mmw" "nei" "5" )
lxGenFromSource( cv_schematic )
cv_layout = dbOpenCellViewByType("tcoil" "tcoil_master" "layout")
MovePinsToInstances( cv_schematic cv_layout )
StreamOutGDS("tcoil" "tcoil_master" "layout" "/autofs/fs1.ece/fs1.eecg.tcc/lizongh2/gf22x-1020b/EMX_work/tcoil_tcoil2708.work" "tcoil2708.gds")

cv_schematic = dbOpenCellViewByType("tcoil" "tcoil_master" "schematic")
CCSchangeParam( "tcoil" "tcoil_master" "schematic" "tcoil3_mmw" "pneo" "60" )
CCSchangeParam( "tcoil" "tcoil_master" "schematic" "tcoil3_mmw" "ctapLocation" "bot" )
CCSchangeParam( "tcoil" "tcoil_master" "schematic" "tcoil3_mmw" "od" "52u" )
CCSchangeParam( "tcoil" "tcoil_master" "schematic" "tcoil3_mmw" "w" "5.0u" )
CCSchangeParam( "tcoil" "tcoil_master" "schematic" "tcoil3_mmw" "neo" "12" )
CCSchangeParam( "tcoil" "tcoil_master" "schematic" "tcoil3_mmw" "nei" "5" )
lxGenFromSource( cv_schematic )
cv_layout = dbOpenCellViewByType("tcoil" "tcoil_master" "layout")
MovePinsToInstances( cv_schematic cv_layout )
StreamOutGDS("tcoil" "tcoil_master" "layout" "/autofs/fs1.ece/fs1.eecg.tcc/lizongh2/gf22x-1020b/EMX_work/tcoil_tcoil2709.work" "tcoil2709.gds")

cv_schematic = dbOpenCellViewByType("tcoil" "tcoil_master" "schematic")
CCSchangeParam( "tcoil" "tcoil_master" "schematic" "tcoil3_mmw" "pneo" "60" )
CCSchangeParam( "tcoil" "tcoil_master" "schematic" "tcoil3_mmw" "ctapLocation" "bot" )
CCSchangeParam( "tcoil" "tcoil_master" "schematic" "tcoil3_mmw" "od" "54u" )
CCSchangeParam( "tcoil" "tcoil_master" "schematic" "tcoil3_mmw" "w" "2.4u" )
CCSchangeParam( "tcoil" "tcoil_master" "schematic" "tcoil3_mmw" "neo" "4" )
CCSchangeParam( "tcoil" "tcoil_master" "schematic" "tcoil3_mmw" "nei" "5" )
lxGenFromSource( cv_schematic )
cv_layout = dbOpenCellViewByType("tcoil" "tcoil_master" "layout")
MovePinsToInstances( cv_schematic cv_layout )
StreamOutGDS("tcoil" "tcoil_master" "layout" "/autofs/fs1.ece/fs1.eecg.tcc/lizongh2/gf22x-1020b/EMX_work/tcoil_tcoil2710.work" "tcoil2710.gds")

cv_schematic = dbOpenCellViewByType("tcoil" "tcoil_master" "schematic")
CCSchangeParam( "tcoil" "tcoil_master" "schematic" "tcoil3_mmw" "pneo" "60" )
CCSchangeParam( "tcoil" "tcoil_master" "schematic" "tcoil3_mmw" "ctapLocation" "bot" )
CCSchangeParam( "tcoil" "tcoil_master" "schematic" "tcoil3_mmw" "od" "54u" )
CCSchangeParam( "tcoil" "tcoil_master" "schematic" "tcoil3_mmw" "w" "2.4u" )
CCSchangeParam( "tcoil" "tcoil_master" "schematic" "tcoil3_mmw" "neo" "6" )
CCSchangeParam( "tcoil" "tcoil_master" "schematic" "tcoil3_mmw" "nei" "5" )
lxGenFromSource( cv_schematic )
cv_layout = dbOpenCellViewByType("tcoil" "tcoil_master" "layout")
MovePinsToInstances( cv_schematic cv_layout )
StreamOutGDS("tcoil" "tcoil_master" "layout" "/autofs/fs1.ece/fs1.eecg.tcc/lizongh2/gf22x-1020b/EMX_work/tcoil_tcoil2711.work" "tcoil2711.gds")

cv_schematic = dbOpenCellViewByType("tcoil" "tcoil_master" "schematic")
CCSchangeParam( "tcoil" "tcoil_master" "schematic" "tcoil3_mmw" "pneo" "60" )
CCSchangeParam( "tcoil" "tcoil_master" "schematic" "tcoil3_mmw" "ctapLocation" "bot" )
CCSchangeParam( "tcoil" "tcoil_master" "schematic" "tcoil3_mmw" "od" "54u" )
CCSchangeParam( "tcoil" "tcoil_master" "schematic" "tcoil3_mmw" "w" "2.4u" )
CCSchangeParam( "tcoil" "tcoil_master" "schematic" "tcoil3_mmw" "neo" "8" )
CCSchangeParam( "tcoil" "tcoil_master" "schematic" "tcoil3_mmw" "nei" "5" )
lxGenFromSource( cv_schematic )
cv_layout = dbOpenCellViewByType("tcoil" "tcoil_master" "layout")
MovePinsToInstances( cv_schematic cv_layout )
StreamOutGDS("tcoil" "tcoil_master" "layout" "/autofs/fs1.ece/fs1.eecg.tcc/lizongh2/gf22x-1020b/EMX_work/tcoil_tcoil2712.work" "tcoil2712.gds")

cv_schematic = dbOpenCellViewByType("tcoil" "tcoil_master" "schematic")
CCSchangeParam( "tcoil" "tcoil_master" "schematic" "tcoil3_mmw" "pneo" "60" )
CCSchangeParam( "tcoil" "tcoil_master" "schematic" "tcoil3_mmw" "ctapLocation" "bot" )
CCSchangeParam( "tcoil" "tcoil_master" "schematic" "tcoil3_mmw" "od" "54u" )
CCSchangeParam( "tcoil" "tcoil_master" "schematic" "tcoil3_mmw" "w" "2.4u" )
CCSchangeParam( "tcoil" "tcoil_master" "schematic" "tcoil3_mmw" "neo" "10" )
CCSchangeParam( "tcoil" "tcoil_master" "schematic" "tcoil3_mmw" "nei" "5" )
lxGenFromSource( cv_schematic )
cv_layout = dbOpenCellViewByType("tcoil" "tcoil_master" "layout")
MovePinsToInstances( cv_schematic cv_layout )
StreamOutGDS("tcoil" "tcoil_master" "layout" "/autofs/fs1.ece/fs1.eecg.tcc/lizongh2/gf22x-1020b/EMX_work/tcoil_tcoil2713.work" "tcoil2713.gds")

cv_schematic = dbOpenCellViewByType("tcoil" "tcoil_master" "schematic")
CCSchangeParam( "tcoil" "tcoil_master" "schematic" "tcoil3_mmw" "pneo" "60" )
CCSchangeParam( "tcoil" "tcoil_master" "schematic" "tcoil3_mmw" "ctapLocation" "bot" )
CCSchangeParam( "tcoil" "tcoil_master" "schematic" "tcoil3_mmw" "od" "54u" )
CCSchangeParam( "tcoil" "tcoil_master" "schematic" "tcoil3_mmw" "w" "2.4u" )
CCSchangeParam( "tcoil" "tcoil_master" "schematic" "tcoil3_mmw" "neo" "12" )
CCSchangeParam( "tcoil" "tcoil_master" "schematic" "tcoil3_mmw" "nei" "5" )
lxGenFromSource( cv_schematic )
cv_layout = dbOpenCellViewByType("tcoil" "tcoil_master" "layout")
MovePinsToInstances( cv_schematic cv_layout )
StreamOutGDS("tcoil" "tcoil_master" "layout" "/autofs/fs1.ece/fs1.eecg.tcc/lizongh2/gf22x-1020b/EMX_work/tcoil_tcoil2714.work" "tcoil2714.gds")

cv_schematic = dbOpenCellViewByType("tcoil" "tcoil_master" "schematic")
CCSchangeParam( "tcoil" "tcoil_master" "schematic" "tcoil3_mmw" "pneo" "60" )
CCSchangeParam( "tcoil" "tcoil_master" "schematic" "tcoil3_mmw" "ctapLocation" "bot" )
CCSchangeParam( "tcoil" "tcoil_master" "schematic" "tcoil3_mmw" "od" "54u" )
CCSchangeParam( "tcoil" "tcoil_master" "schematic" "tcoil3_mmw" "w" "4.2u" )
CCSchangeParam( "tcoil" "tcoil_master" "schematic" "tcoil3_mmw" "neo" "4" )
CCSchangeParam( "tcoil" "tcoil_master" "schematic" "tcoil3_mmw" "nei" "5" )
lxGenFromSource( cv_schematic )
cv_layout = dbOpenCellViewByType("tcoil" "tcoil_master" "layout")
MovePinsToInstances( cv_schematic cv_layout )
StreamOutGDS("tcoil" "tcoil_master" "layout" "/autofs/fs1.ece/fs1.eecg.tcc/lizongh2/gf22x-1020b/EMX_work/tcoil_tcoil2715.work" "tcoil2715.gds")

cv_schematic = dbOpenCellViewByType("tcoil" "tcoil_master" "schematic")
CCSchangeParam( "tcoil" "tcoil_master" "schematic" "tcoil3_mmw" "pneo" "60" )
CCSchangeParam( "tcoil" "tcoil_master" "schematic" "tcoil3_mmw" "ctapLocation" "bot" )
CCSchangeParam( "tcoil" "tcoil_master" "schematic" "tcoil3_mmw" "od" "54u" )
CCSchangeParam( "tcoil" "tcoil_master" "schematic" "tcoil3_mmw" "w" "4.2u" )
CCSchangeParam( "tcoil" "tcoil_master" "schematic" "tcoil3_mmw" "neo" "6" )
CCSchangeParam( "tcoil" "tcoil_master" "schematic" "tcoil3_mmw" "nei" "5" )
lxGenFromSource( cv_schematic )
cv_layout = dbOpenCellViewByType("tcoil" "tcoil_master" "layout")
MovePinsToInstances( cv_schematic cv_layout )
StreamOutGDS("tcoil" "tcoil_master" "layout" "/autofs/fs1.ece/fs1.eecg.tcc/lizongh2/gf22x-1020b/EMX_work/tcoil_tcoil2716.work" "tcoil2716.gds")

cv_schematic = dbOpenCellViewByType("tcoil" "tcoil_master" "schematic")
CCSchangeParam( "tcoil" "tcoil_master" "schematic" "tcoil3_mmw" "pneo" "60" )
CCSchangeParam( "tcoil" "tcoil_master" "schematic" "tcoil3_mmw" "ctapLocation" "bot" )
CCSchangeParam( "tcoil" "tcoil_master" "schematic" "tcoil3_mmw" "od" "54u" )
CCSchangeParam( "tcoil" "tcoil_master" "schematic" "tcoil3_mmw" "w" "4.2u" )
CCSchangeParam( "tcoil" "tcoil_master" "schematic" "tcoil3_mmw" "neo" "8" )
CCSchangeParam( "tcoil" "tcoil_master" "schematic" "tcoil3_mmw" "nei" "5" )
lxGenFromSource( cv_schematic )
cv_layout = dbOpenCellViewByType("tcoil" "tcoil_master" "layout")
MovePinsToInstances( cv_schematic cv_layout )
StreamOutGDS("tcoil" "tcoil_master" "layout" "/autofs/fs1.ece/fs1.eecg.tcc/lizongh2/gf22x-1020b/EMX_work/tcoil_tcoil2717.work" "tcoil2717.gds")

cv_schematic = dbOpenCellViewByType("tcoil" "tcoil_master" "schematic")
CCSchangeParam( "tcoil" "tcoil_master" "schematic" "tcoil3_mmw" "pneo" "60" )
CCSchangeParam( "tcoil" "tcoil_master" "schematic" "tcoil3_mmw" "ctapLocation" "bot" )
CCSchangeParam( "tcoil" "tcoil_master" "schematic" "tcoil3_mmw" "od" "54u" )
CCSchangeParam( "tcoil" "tcoil_master" "schematic" "tcoil3_mmw" "w" "4.2u" )
CCSchangeParam( "tcoil" "tcoil_master" "schematic" "tcoil3_mmw" "neo" "10" )
CCSchangeParam( "tcoil" "tcoil_master" "schematic" "tcoil3_mmw" "nei" "5" )
lxGenFromSource( cv_schematic )
cv_layout = dbOpenCellViewByType("tcoil" "tcoil_master" "layout")
MovePinsToInstances( cv_schematic cv_layout )
StreamOutGDS("tcoil" "tcoil_master" "layout" "/autofs/fs1.ece/fs1.eecg.tcc/lizongh2/gf22x-1020b/EMX_work/tcoil_tcoil2718.work" "tcoil2718.gds")

cv_schematic = dbOpenCellViewByType("tcoil" "tcoil_master" "schematic")
CCSchangeParam( "tcoil" "tcoil_master" "schematic" "tcoil3_mmw" "pneo" "60" )
CCSchangeParam( "tcoil" "tcoil_master" "schematic" "tcoil3_mmw" "ctapLocation" "bot" )
CCSchangeParam( "tcoil" "tcoil_master" "schematic" "tcoil3_mmw" "od" "54u" )
CCSchangeParam( "tcoil" "tcoil_master" "schematic" "tcoil3_mmw" "w" "4.2u" )
CCSchangeParam( "tcoil" "tcoil_master" "schematic" "tcoil3_mmw" "neo" "12" )
CCSchangeParam( "tcoil" "tcoil_master" "schematic" "tcoil3_mmw" "nei" "5" )
lxGenFromSource( cv_schematic )
cv_layout = dbOpenCellViewByType("tcoil" "tcoil_master" "layout")
MovePinsToInstances( cv_schematic cv_layout )
StreamOutGDS("tcoil" "tcoil_master" "layout" "/autofs/fs1.ece/fs1.eecg.tcc/lizongh2/gf22x-1020b/EMX_work/tcoil_tcoil2719.work" "tcoil2719.gds")

cv_schematic = dbOpenCellViewByType("tcoil" "tcoil_master" "schematic")
CCSchangeParam( "tcoil" "tcoil_master" "schematic" "tcoil3_mmw" "pneo" "60" )
CCSchangeParam( "tcoil" "tcoil_master" "schematic" "tcoil3_mmw" "ctapLocation" "bot" )
CCSchangeParam( "tcoil" "tcoil_master" "schematic" "tcoil3_mmw" "od" "54u" )
CCSchangeParam( "tcoil" "tcoil_master" "schematic" "tcoil3_mmw" "w" "5.0u" )
CCSchangeParam( "tcoil" "tcoil_master" "schematic" "tcoil3_mmw" "neo" "4" )
CCSchangeParam( "tcoil" "tcoil_master" "schematic" "tcoil3_mmw" "nei" "5" )
lxGenFromSource( cv_schematic )
cv_layout = dbOpenCellViewByType("tcoil" "tcoil_master" "layout")
MovePinsToInstances( cv_schematic cv_layout )
StreamOutGDS("tcoil" "tcoil_master" "layout" "/autofs/fs1.ece/fs1.eecg.tcc/lizongh2/gf22x-1020b/EMX_work/tcoil_tcoil2720.work" "tcoil2720.gds")

cv_schematic = dbOpenCellViewByType("tcoil" "tcoil_master" "schematic")
CCSchangeParam( "tcoil" "tcoil_master" "schematic" "tcoil3_mmw" "pneo" "60" )
CCSchangeParam( "tcoil" "tcoil_master" "schematic" "tcoil3_mmw" "ctapLocation" "bot" )
CCSchangeParam( "tcoil" "tcoil_master" "schematic" "tcoil3_mmw" "od" "54u" )
CCSchangeParam( "tcoil" "tcoil_master" "schematic" "tcoil3_mmw" "w" "5.0u" )
CCSchangeParam( "tcoil" "tcoil_master" "schematic" "tcoil3_mmw" "neo" "6" )
CCSchangeParam( "tcoil" "tcoil_master" "schematic" "tcoil3_mmw" "nei" "5" )
lxGenFromSource( cv_schematic )
cv_layout = dbOpenCellViewByType("tcoil" "tcoil_master" "layout")
MovePinsToInstances( cv_schematic cv_layout )
StreamOutGDS("tcoil" "tcoil_master" "layout" "/autofs/fs1.ece/fs1.eecg.tcc/lizongh2/gf22x-1020b/EMX_work/tcoil_tcoil2721.work" "tcoil2721.gds")

cv_schematic = dbOpenCellViewByType("tcoil" "tcoil_master" "schematic")
CCSchangeParam( "tcoil" "tcoil_master" "schematic" "tcoil3_mmw" "pneo" "60" )
CCSchangeParam( "tcoil" "tcoil_master" "schematic" "tcoil3_mmw" "ctapLocation" "bot" )
CCSchangeParam( "tcoil" "tcoil_master" "schematic" "tcoil3_mmw" "od" "54u" )
CCSchangeParam( "tcoil" "tcoil_master" "schematic" "tcoil3_mmw" "w" "5.0u" )
CCSchangeParam( "tcoil" "tcoil_master" "schematic" "tcoil3_mmw" "neo" "8" )
CCSchangeParam( "tcoil" "tcoil_master" "schematic" "tcoil3_mmw" "nei" "5" )
lxGenFromSource( cv_schematic )
cv_layout = dbOpenCellViewByType("tcoil" "tcoil_master" "layout")
MovePinsToInstances( cv_schematic cv_layout )
StreamOutGDS("tcoil" "tcoil_master" "layout" "/autofs/fs1.ece/fs1.eecg.tcc/lizongh2/gf22x-1020b/EMX_work/tcoil_tcoil2722.work" "tcoil2722.gds")

cv_schematic = dbOpenCellViewByType("tcoil" "tcoil_master" "schematic")
CCSchangeParam( "tcoil" "tcoil_master" "schematic" "tcoil3_mmw" "pneo" "60" )
CCSchangeParam( "tcoil" "tcoil_master" "schematic" "tcoil3_mmw" "ctapLocation" "bot" )
CCSchangeParam( "tcoil" "tcoil_master" "schematic" "tcoil3_mmw" "od" "54u" )
CCSchangeParam( "tcoil" "tcoil_master" "schematic" "tcoil3_mmw" "w" "5.0u" )
CCSchangeParam( "tcoil" "tcoil_master" "schematic" "tcoil3_mmw" "neo" "10" )
CCSchangeParam( "tcoil" "tcoil_master" "schematic" "tcoil3_mmw" "nei" "5" )
lxGenFromSource( cv_schematic )
cv_layout = dbOpenCellViewByType("tcoil" "tcoil_master" "layout")
MovePinsToInstances( cv_schematic cv_layout )
StreamOutGDS("tcoil" "tcoil_master" "layout" "/autofs/fs1.ece/fs1.eecg.tcc/lizongh2/gf22x-1020b/EMX_work/tcoil_tcoil2723.work" "tcoil2723.gds")

cv_schematic = dbOpenCellViewByType("tcoil" "tcoil_master" "schematic")
CCSchangeParam( "tcoil" "tcoil_master" "schematic" "tcoil3_mmw" "pneo" "60" )
CCSchangeParam( "tcoil" "tcoil_master" "schematic" "tcoil3_mmw" "ctapLocation" "bot" )
CCSchangeParam( "tcoil" "tcoil_master" "schematic" "tcoil3_mmw" "od" "54u" )
CCSchangeParam( "tcoil" "tcoil_master" "schematic" "tcoil3_mmw" "w" "5.0u" )
CCSchangeParam( "tcoil" "tcoil_master" "schematic" "tcoil3_mmw" "neo" "12" )
CCSchangeParam( "tcoil" "tcoil_master" "schematic" "tcoil3_mmw" "nei" "5" )
lxGenFromSource( cv_schematic )
cv_layout = dbOpenCellViewByType("tcoil" "tcoil_master" "layout")
MovePinsToInstances( cv_schematic cv_layout )
StreamOutGDS("tcoil" "tcoil_master" "layout" "/autofs/fs1.ece/fs1.eecg.tcc/lizongh2/gf22x-1020b/EMX_work/tcoil_tcoil2724.work" "tcoil2724.gds")

cv_schematic = dbOpenCellViewByType("tcoil" "tcoil_master" "schematic")
CCSchangeParam( "tcoil" "tcoil_master" "schematic" "tcoil3_mmw" "pneo" "60" )
CCSchangeParam( "tcoil" "tcoil_master" "schematic" "tcoil3_mmw" "ctapLocation" "bot" )
CCSchangeParam( "tcoil" "tcoil_master" "schematic" "tcoil3_mmw" "od" "56u" )
CCSchangeParam( "tcoil" "tcoil_master" "schematic" "tcoil3_mmw" "w" "2.4u" )
CCSchangeParam( "tcoil" "tcoil_master" "schematic" "tcoil3_mmw" "neo" "4" )
CCSchangeParam( "tcoil" "tcoil_master" "schematic" "tcoil3_mmw" "nei" "5" )
lxGenFromSource( cv_schematic )
cv_layout = dbOpenCellViewByType("tcoil" "tcoil_master" "layout")
MovePinsToInstances( cv_schematic cv_layout )
StreamOutGDS("tcoil" "tcoil_master" "layout" "/autofs/fs1.ece/fs1.eecg.tcc/lizongh2/gf22x-1020b/EMX_work/tcoil_tcoil2725.work" "tcoil2725.gds")

cv_schematic = dbOpenCellViewByType("tcoil" "tcoil_master" "schematic")
CCSchangeParam( "tcoil" "tcoil_master" "schematic" "tcoil3_mmw" "pneo" "60" )
CCSchangeParam( "tcoil" "tcoil_master" "schematic" "tcoil3_mmw" "ctapLocation" "bot" )
CCSchangeParam( "tcoil" "tcoil_master" "schematic" "tcoil3_mmw" "od" "56u" )
CCSchangeParam( "tcoil" "tcoil_master" "schematic" "tcoil3_mmw" "w" "2.4u" )
CCSchangeParam( "tcoil" "tcoil_master" "schematic" "tcoil3_mmw" "neo" "6" )
CCSchangeParam( "tcoil" "tcoil_master" "schematic" "tcoil3_mmw" "nei" "5" )
lxGenFromSource( cv_schematic )
cv_layout = dbOpenCellViewByType("tcoil" "tcoil_master" "layout")
MovePinsToInstances( cv_schematic cv_layout )
StreamOutGDS("tcoil" "tcoil_master" "layout" "/autofs/fs1.ece/fs1.eecg.tcc/lizongh2/gf22x-1020b/EMX_work/tcoil_tcoil2726.work" "tcoil2726.gds")

cv_schematic = dbOpenCellViewByType("tcoil" "tcoil_master" "schematic")
CCSchangeParam( "tcoil" "tcoil_master" "schematic" "tcoil3_mmw" "pneo" "60" )
CCSchangeParam( "tcoil" "tcoil_master" "schematic" "tcoil3_mmw" "ctapLocation" "bot" )
CCSchangeParam( "tcoil" "tcoil_master" "schematic" "tcoil3_mmw" "od" "56u" )
CCSchangeParam( "tcoil" "tcoil_master" "schematic" "tcoil3_mmw" "w" "2.4u" )
CCSchangeParam( "tcoil" "tcoil_master" "schematic" "tcoil3_mmw" "neo" "8" )
CCSchangeParam( "tcoil" "tcoil_master" "schematic" "tcoil3_mmw" "nei" "5" )
lxGenFromSource( cv_schematic )
cv_layout = dbOpenCellViewByType("tcoil" "tcoil_master" "layout")
MovePinsToInstances( cv_schematic cv_layout )
StreamOutGDS("tcoil" "tcoil_master" "layout" "/autofs/fs1.ece/fs1.eecg.tcc/lizongh2/gf22x-1020b/EMX_work/tcoil_tcoil2727.work" "tcoil2727.gds")

cv_schematic = dbOpenCellViewByType("tcoil" "tcoil_master" "schematic")
CCSchangeParam( "tcoil" "tcoil_master" "schematic" "tcoil3_mmw" "pneo" "60" )
CCSchangeParam( "tcoil" "tcoil_master" "schematic" "tcoil3_mmw" "ctapLocation" "bot" )
CCSchangeParam( "tcoil" "tcoil_master" "schematic" "tcoil3_mmw" "od" "56u" )
CCSchangeParam( "tcoil" "tcoil_master" "schematic" "tcoil3_mmw" "w" "2.4u" )
CCSchangeParam( "tcoil" "tcoil_master" "schematic" "tcoil3_mmw" "neo" "10" )
CCSchangeParam( "tcoil" "tcoil_master" "schematic" "tcoil3_mmw" "nei" "5" )
lxGenFromSource( cv_schematic )
cv_layout = dbOpenCellViewByType("tcoil" "tcoil_master" "layout")
MovePinsToInstances( cv_schematic cv_layout )
StreamOutGDS("tcoil" "tcoil_master" "layout" "/autofs/fs1.ece/fs1.eecg.tcc/lizongh2/gf22x-1020b/EMX_work/tcoil_tcoil2728.work" "tcoil2728.gds")

cv_schematic = dbOpenCellViewByType("tcoil" "tcoil_master" "schematic")
CCSchangeParam( "tcoil" "tcoil_master" "schematic" "tcoil3_mmw" "pneo" "60" )
CCSchangeParam( "tcoil" "tcoil_master" "schematic" "tcoil3_mmw" "ctapLocation" "bot" )
CCSchangeParam( "tcoil" "tcoil_master" "schematic" "tcoil3_mmw" "od" "56u" )
CCSchangeParam( "tcoil" "tcoil_master" "schematic" "tcoil3_mmw" "w" "2.4u" )
CCSchangeParam( "tcoil" "tcoil_master" "schematic" "tcoil3_mmw" "neo" "12" )
CCSchangeParam( "tcoil" "tcoil_master" "schematic" "tcoil3_mmw" "nei" "5" )
lxGenFromSource( cv_schematic )
cv_layout = dbOpenCellViewByType("tcoil" "tcoil_master" "layout")
MovePinsToInstances( cv_schematic cv_layout )
StreamOutGDS("tcoil" "tcoil_master" "layout" "/autofs/fs1.ece/fs1.eecg.tcc/lizongh2/gf22x-1020b/EMX_work/tcoil_tcoil2729.work" "tcoil2729.gds")

cv_schematic = dbOpenCellViewByType("tcoil" "tcoil_master" "schematic")
CCSchangeParam( "tcoil" "tcoil_master" "schematic" "tcoil3_mmw" "pneo" "60" )
CCSchangeParam( "tcoil" "tcoil_master" "schematic" "tcoil3_mmw" "ctapLocation" "bot" )
CCSchangeParam( "tcoil" "tcoil_master" "schematic" "tcoil3_mmw" "od" "56u" )
CCSchangeParam( "tcoil" "tcoil_master" "schematic" "tcoil3_mmw" "w" "4.2u" )
CCSchangeParam( "tcoil" "tcoil_master" "schematic" "tcoil3_mmw" "neo" "4" )
CCSchangeParam( "tcoil" "tcoil_master" "schematic" "tcoil3_mmw" "nei" "5" )
lxGenFromSource( cv_schematic )
cv_layout = dbOpenCellViewByType("tcoil" "tcoil_master" "layout")
MovePinsToInstances( cv_schematic cv_layout )
StreamOutGDS("tcoil" "tcoil_master" "layout" "/autofs/fs1.ece/fs1.eecg.tcc/lizongh2/gf22x-1020b/EMX_work/tcoil_tcoil2730.work" "tcoil2730.gds")

cv_schematic = dbOpenCellViewByType("tcoil" "tcoil_master" "schematic")
CCSchangeParam( "tcoil" "tcoil_master" "schematic" "tcoil3_mmw" "pneo" "60" )
CCSchangeParam( "tcoil" "tcoil_master" "schematic" "tcoil3_mmw" "ctapLocation" "bot" )
CCSchangeParam( "tcoil" "tcoil_master" "schematic" "tcoil3_mmw" "od" "56u" )
CCSchangeParam( "tcoil" "tcoil_master" "schematic" "tcoil3_mmw" "w" "4.2u" )
CCSchangeParam( "tcoil" "tcoil_master" "schematic" "tcoil3_mmw" "neo" "6" )
CCSchangeParam( "tcoil" "tcoil_master" "schematic" "tcoil3_mmw" "nei" "5" )
lxGenFromSource( cv_schematic )
cv_layout = dbOpenCellViewByType("tcoil" "tcoil_master" "layout")
MovePinsToInstances( cv_schematic cv_layout )
StreamOutGDS("tcoil" "tcoil_master" "layout" "/autofs/fs1.ece/fs1.eecg.tcc/lizongh2/gf22x-1020b/EMX_work/tcoil_tcoil2731.work" "tcoil2731.gds")

cv_schematic = dbOpenCellViewByType("tcoil" "tcoil_master" "schematic")
CCSchangeParam( "tcoil" "tcoil_master" "schematic" "tcoil3_mmw" "pneo" "60" )
CCSchangeParam( "tcoil" "tcoil_master" "schematic" "tcoil3_mmw" "ctapLocation" "bot" )
CCSchangeParam( "tcoil" "tcoil_master" "schematic" "tcoil3_mmw" "od" "56u" )
CCSchangeParam( "tcoil" "tcoil_master" "schematic" "tcoil3_mmw" "w" "4.2u" )
CCSchangeParam( "tcoil" "tcoil_master" "schematic" "tcoil3_mmw" "neo" "8" )
CCSchangeParam( "tcoil" "tcoil_master" "schematic" "tcoil3_mmw" "nei" "5" )
lxGenFromSource( cv_schematic )
cv_layout = dbOpenCellViewByType("tcoil" "tcoil_master" "layout")
MovePinsToInstances( cv_schematic cv_layout )
StreamOutGDS("tcoil" "tcoil_master" "layout" "/autofs/fs1.ece/fs1.eecg.tcc/lizongh2/gf22x-1020b/EMX_work/tcoil_tcoil2732.work" "tcoil2732.gds")

cv_schematic = dbOpenCellViewByType("tcoil" "tcoil_master" "schematic")
CCSchangeParam( "tcoil" "tcoil_master" "schematic" "tcoil3_mmw" "pneo" "60" )
CCSchangeParam( "tcoil" "tcoil_master" "schematic" "tcoil3_mmw" "ctapLocation" "bot" )
CCSchangeParam( "tcoil" "tcoil_master" "schematic" "tcoil3_mmw" "od" "56u" )
CCSchangeParam( "tcoil" "tcoil_master" "schematic" "tcoil3_mmw" "w" "4.2u" )
CCSchangeParam( "tcoil" "tcoil_master" "schematic" "tcoil3_mmw" "neo" "10" )
CCSchangeParam( "tcoil" "tcoil_master" "schematic" "tcoil3_mmw" "nei" "5" )
lxGenFromSource( cv_schematic )
cv_layout = dbOpenCellViewByType("tcoil" "tcoil_master" "layout")
MovePinsToInstances( cv_schematic cv_layout )
StreamOutGDS("tcoil" "tcoil_master" "layout" "/autofs/fs1.ece/fs1.eecg.tcc/lizongh2/gf22x-1020b/EMX_work/tcoil_tcoil2733.work" "tcoil2733.gds")

cv_schematic = dbOpenCellViewByType("tcoil" "tcoil_master" "schematic")
CCSchangeParam( "tcoil" "tcoil_master" "schematic" "tcoil3_mmw" "pneo" "60" )
CCSchangeParam( "tcoil" "tcoil_master" "schematic" "tcoil3_mmw" "ctapLocation" "bot" )
CCSchangeParam( "tcoil" "tcoil_master" "schematic" "tcoil3_mmw" "od" "56u" )
CCSchangeParam( "tcoil" "tcoil_master" "schematic" "tcoil3_mmw" "w" "4.2u" )
CCSchangeParam( "tcoil" "tcoil_master" "schematic" "tcoil3_mmw" "neo" "12" )
CCSchangeParam( "tcoil" "tcoil_master" "schematic" "tcoil3_mmw" "nei" "5" )
lxGenFromSource( cv_schematic )
cv_layout = dbOpenCellViewByType("tcoil" "tcoil_master" "layout")
MovePinsToInstances( cv_schematic cv_layout )
StreamOutGDS("tcoil" "tcoil_master" "layout" "/autofs/fs1.ece/fs1.eecg.tcc/lizongh2/gf22x-1020b/EMX_work/tcoil_tcoil2734.work" "tcoil2734.gds")

cv_schematic = dbOpenCellViewByType("tcoil" "tcoil_master" "schematic")
CCSchangeParam( "tcoil" "tcoil_master" "schematic" "tcoil3_mmw" "pneo" "60" )
CCSchangeParam( "tcoil" "tcoil_master" "schematic" "tcoil3_mmw" "ctapLocation" "bot" )
CCSchangeParam( "tcoil" "tcoil_master" "schematic" "tcoil3_mmw" "od" "56u" )
CCSchangeParam( "tcoil" "tcoil_master" "schematic" "tcoil3_mmw" "w" "5.0u" )
CCSchangeParam( "tcoil" "tcoil_master" "schematic" "tcoil3_mmw" "neo" "4" )
CCSchangeParam( "tcoil" "tcoil_master" "schematic" "tcoil3_mmw" "nei" "5" )
lxGenFromSource( cv_schematic )
cv_layout = dbOpenCellViewByType("tcoil" "tcoil_master" "layout")
MovePinsToInstances( cv_schematic cv_layout )
StreamOutGDS("tcoil" "tcoil_master" "layout" "/autofs/fs1.ece/fs1.eecg.tcc/lizongh2/gf22x-1020b/EMX_work/tcoil_tcoil2735.work" "tcoil2735.gds")

cv_schematic = dbOpenCellViewByType("tcoil" "tcoil_master" "schematic")
CCSchangeParam( "tcoil" "tcoil_master" "schematic" "tcoil3_mmw" "pneo" "60" )
CCSchangeParam( "tcoil" "tcoil_master" "schematic" "tcoil3_mmw" "ctapLocation" "bot" )
CCSchangeParam( "tcoil" "tcoil_master" "schematic" "tcoil3_mmw" "od" "56u" )
CCSchangeParam( "tcoil" "tcoil_master" "schematic" "tcoil3_mmw" "w" "5.0u" )
CCSchangeParam( "tcoil" "tcoil_master" "schematic" "tcoil3_mmw" "neo" "6" )
CCSchangeParam( "tcoil" "tcoil_master" "schematic" "tcoil3_mmw" "nei" "5" )
lxGenFromSource( cv_schematic )
cv_layout = dbOpenCellViewByType("tcoil" "tcoil_master" "layout")
MovePinsToInstances( cv_schematic cv_layout )
StreamOutGDS("tcoil" "tcoil_master" "layout" "/autofs/fs1.ece/fs1.eecg.tcc/lizongh2/gf22x-1020b/EMX_work/tcoil_tcoil2736.work" "tcoil2736.gds")

cv_schematic = dbOpenCellViewByType("tcoil" "tcoil_master" "schematic")
CCSchangeParam( "tcoil" "tcoil_master" "schematic" "tcoil3_mmw" "pneo" "60" )
CCSchangeParam( "tcoil" "tcoil_master" "schematic" "tcoil3_mmw" "ctapLocation" "bot" )
CCSchangeParam( "tcoil" "tcoil_master" "schematic" "tcoil3_mmw" "od" "56u" )
CCSchangeParam( "tcoil" "tcoil_master" "schematic" "tcoil3_mmw" "w" "5.0u" )
CCSchangeParam( "tcoil" "tcoil_master" "schematic" "tcoil3_mmw" "neo" "8" )
CCSchangeParam( "tcoil" "tcoil_master" "schematic" "tcoil3_mmw" "nei" "5" )
lxGenFromSource( cv_schematic )
cv_layout = dbOpenCellViewByType("tcoil" "tcoil_master" "layout")
MovePinsToInstances( cv_schematic cv_layout )
StreamOutGDS("tcoil" "tcoil_master" "layout" "/autofs/fs1.ece/fs1.eecg.tcc/lizongh2/gf22x-1020b/EMX_work/tcoil_tcoil2737.work" "tcoil2737.gds")

cv_schematic = dbOpenCellViewByType("tcoil" "tcoil_master" "schematic")
CCSchangeParam( "tcoil" "tcoil_master" "schematic" "tcoil3_mmw" "pneo" "60" )
CCSchangeParam( "tcoil" "tcoil_master" "schematic" "tcoil3_mmw" "ctapLocation" "bot" )
CCSchangeParam( "tcoil" "tcoil_master" "schematic" "tcoil3_mmw" "od" "56u" )
CCSchangeParam( "tcoil" "tcoil_master" "schematic" "tcoil3_mmw" "w" "5.0u" )
CCSchangeParam( "tcoil" "tcoil_master" "schematic" "tcoil3_mmw" "neo" "10" )
CCSchangeParam( "tcoil" "tcoil_master" "schematic" "tcoil3_mmw" "nei" "5" )
lxGenFromSource( cv_schematic )
cv_layout = dbOpenCellViewByType("tcoil" "tcoil_master" "layout")
MovePinsToInstances( cv_schematic cv_layout )
StreamOutGDS("tcoil" "tcoil_master" "layout" "/autofs/fs1.ece/fs1.eecg.tcc/lizongh2/gf22x-1020b/EMX_work/tcoil_tcoil2738.work" "tcoil2738.gds")

cv_schematic = dbOpenCellViewByType("tcoil" "tcoil_master" "schematic")
CCSchangeParam( "tcoil" "tcoil_master" "schematic" "tcoil3_mmw" "pneo" "60" )
CCSchangeParam( "tcoil" "tcoil_master" "schematic" "tcoil3_mmw" "ctapLocation" "bot" )
CCSchangeParam( "tcoil" "tcoil_master" "schematic" "tcoil3_mmw" "od" "56u" )
CCSchangeParam( "tcoil" "tcoil_master" "schematic" "tcoil3_mmw" "w" "5.0u" )
CCSchangeParam( "tcoil" "tcoil_master" "schematic" "tcoil3_mmw" "neo" "12" )
CCSchangeParam( "tcoil" "tcoil_master" "schematic" "tcoil3_mmw" "nei" "5" )
lxGenFromSource( cv_schematic )
cv_layout = dbOpenCellViewByType("tcoil" "tcoil_master" "layout")
MovePinsToInstances( cv_schematic cv_layout )
StreamOutGDS("tcoil" "tcoil_master" "layout" "/autofs/fs1.ece/fs1.eecg.tcc/lizongh2/gf22x-1020b/EMX_work/tcoil_tcoil2739.work" "tcoil2739.gds")

cv_schematic = dbOpenCellViewByType("tcoil" "tcoil_master" "schematic")
CCSchangeParam( "tcoil" "tcoil_master" "schematic" "tcoil3_mmw" "pneo" "60" )
CCSchangeParam( "tcoil" "tcoil_master" "schematic" "tcoil3_mmw" "ctapLocation" "bot" )
CCSchangeParam( "tcoil" "tcoil_master" "schematic" "tcoil3_mmw" "od" "58u" )
CCSchangeParam( "tcoil" "tcoil_master" "schematic" "tcoil3_mmw" "w" "2.4u" )
CCSchangeParam( "tcoil" "tcoil_master" "schematic" "tcoil3_mmw" "neo" "4" )
CCSchangeParam( "tcoil" "tcoil_master" "schematic" "tcoil3_mmw" "nei" "5" )
lxGenFromSource( cv_schematic )
cv_layout = dbOpenCellViewByType("tcoil" "tcoil_master" "layout")
MovePinsToInstances( cv_schematic cv_layout )
StreamOutGDS("tcoil" "tcoil_master" "layout" "/autofs/fs1.ece/fs1.eecg.tcc/lizongh2/gf22x-1020b/EMX_work/tcoil_tcoil2740.work" "tcoil2740.gds")

cv_schematic = dbOpenCellViewByType("tcoil" "tcoil_master" "schematic")
CCSchangeParam( "tcoil" "tcoil_master" "schematic" "tcoil3_mmw" "pneo" "60" )
CCSchangeParam( "tcoil" "tcoil_master" "schematic" "tcoil3_mmw" "ctapLocation" "bot" )
CCSchangeParam( "tcoil" "tcoil_master" "schematic" "tcoil3_mmw" "od" "58u" )
CCSchangeParam( "tcoil" "tcoil_master" "schematic" "tcoil3_mmw" "w" "2.4u" )
CCSchangeParam( "tcoil" "tcoil_master" "schematic" "tcoil3_mmw" "neo" "6" )
CCSchangeParam( "tcoil" "tcoil_master" "schematic" "tcoil3_mmw" "nei" "5" )
lxGenFromSource( cv_schematic )
cv_layout = dbOpenCellViewByType("tcoil" "tcoil_master" "layout")
MovePinsToInstances( cv_schematic cv_layout )
StreamOutGDS("tcoil" "tcoil_master" "layout" "/autofs/fs1.ece/fs1.eecg.tcc/lizongh2/gf22x-1020b/EMX_work/tcoil_tcoil2741.work" "tcoil2741.gds")

cv_schematic = dbOpenCellViewByType("tcoil" "tcoil_master" "schematic")
CCSchangeParam( "tcoil" "tcoil_master" "schematic" "tcoil3_mmw" "pneo" "60" )
CCSchangeParam( "tcoil" "tcoil_master" "schematic" "tcoil3_mmw" "ctapLocation" "bot" )
CCSchangeParam( "tcoil" "tcoil_master" "schematic" "tcoil3_mmw" "od" "58u" )
CCSchangeParam( "tcoil" "tcoil_master" "schematic" "tcoil3_mmw" "w" "2.4u" )
CCSchangeParam( "tcoil" "tcoil_master" "schematic" "tcoil3_mmw" "neo" "8" )
CCSchangeParam( "tcoil" "tcoil_master" "schematic" "tcoil3_mmw" "nei" "5" )
lxGenFromSource( cv_schematic )
cv_layout = dbOpenCellViewByType("tcoil" "tcoil_master" "layout")
MovePinsToInstances( cv_schematic cv_layout )
StreamOutGDS("tcoil" "tcoil_master" "layout" "/autofs/fs1.ece/fs1.eecg.tcc/lizongh2/gf22x-1020b/EMX_work/tcoil_tcoil2742.work" "tcoil2742.gds")

cv_schematic = dbOpenCellViewByType("tcoil" "tcoil_master" "schematic")
CCSchangeParam( "tcoil" "tcoil_master" "schematic" "tcoil3_mmw" "pneo" "60" )
CCSchangeParam( "tcoil" "tcoil_master" "schematic" "tcoil3_mmw" "ctapLocation" "bot" )
CCSchangeParam( "tcoil" "tcoil_master" "schematic" "tcoil3_mmw" "od" "58u" )
CCSchangeParam( "tcoil" "tcoil_master" "schematic" "tcoil3_mmw" "w" "2.4u" )
CCSchangeParam( "tcoil" "tcoil_master" "schematic" "tcoil3_mmw" "neo" "10" )
CCSchangeParam( "tcoil" "tcoil_master" "schematic" "tcoil3_mmw" "nei" "5" )
lxGenFromSource( cv_schematic )
cv_layout = dbOpenCellViewByType("tcoil" "tcoil_master" "layout")
MovePinsToInstances( cv_schematic cv_layout )
StreamOutGDS("tcoil" "tcoil_master" "layout" "/autofs/fs1.ece/fs1.eecg.tcc/lizongh2/gf22x-1020b/EMX_work/tcoil_tcoil2743.work" "tcoil2743.gds")

cv_schematic = dbOpenCellViewByType("tcoil" "tcoil_master" "schematic")
CCSchangeParam( "tcoil" "tcoil_master" "schematic" "tcoil3_mmw" "pneo" "60" )
CCSchangeParam( "tcoil" "tcoil_master" "schematic" "tcoil3_mmw" "ctapLocation" "bot" )
CCSchangeParam( "tcoil" "tcoil_master" "schematic" "tcoil3_mmw" "od" "58u" )
CCSchangeParam( "tcoil" "tcoil_master" "schematic" "tcoil3_mmw" "w" "2.4u" )
CCSchangeParam( "tcoil" "tcoil_master" "schematic" "tcoil3_mmw" "neo" "12" )
CCSchangeParam( "tcoil" "tcoil_master" "schematic" "tcoil3_mmw" "nei" "5" )
lxGenFromSource( cv_schematic )
cv_layout = dbOpenCellViewByType("tcoil" "tcoil_master" "layout")
MovePinsToInstances( cv_schematic cv_layout )
StreamOutGDS("tcoil" "tcoil_master" "layout" "/autofs/fs1.ece/fs1.eecg.tcc/lizongh2/gf22x-1020b/EMX_work/tcoil_tcoil2744.work" "tcoil2744.gds")

cv_schematic = dbOpenCellViewByType("tcoil" "tcoil_master" "schematic")
CCSchangeParam( "tcoil" "tcoil_master" "schematic" "tcoil3_mmw" "pneo" "60" )
CCSchangeParam( "tcoil" "tcoil_master" "schematic" "tcoil3_mmw" "ctapLocation" "bot" )
CCSchangeParam( "tcoil" "tcoil_master" "schematic" "tcoil3_mmw" "od" "58u" )
CCSchangeParam( "tcoil" "tcoil_master" "schematic" "tcoil3_mmw" "w" "4.2u" )
CCSchangeParam( "tcoil" "tcoil_master" "schematic" "tcoil3_mmw" "neo" "4" )
CCSchangeParam( "tcoil" "tcoil_master" "schematic" "tcoil3_mmw" "nei" "5" )
lxGenFromSource( cv_schematic )
cv_layout = dbOpenCellViewByType("tcoil" "tcoil_master" "layout")
MovePinsToInstances( cv_schematic cv_layout )
StreamOutGDS("tcoil" "tcoil_master" "layout" "/autofs/fs1.ece/fs1.eecg.tcc/lizongh2/gf22x-1020b/EMX_work/tcoil_tcoil2745.work" "tcoil2745.gds")

cv_schematic = dbOpenCellViewByType("tcoil" "tcoil_master" "schematic")
CCSchangeParam( "tcoil" "tcoil_master" "schematic" "tcoil3_mmw" "pneo" "60" )
CCSchangeParam( "tcoil" "tcoil_master" "schematic" "tcoil3_mmw" "ctapLocation" "bot" )
CCSchangeParam( "tcoil" "tcoil_master" "schematic" "tcoil3_mmw" "od" "58u" )
CCSchangeParam( "tcoil" "tcoil_master" "schematic" "tcoil3_mmw" "w" "4.2u" )
CCSchangeParam( "tcoil" "tcoil_master" "schematic" "tcoil3_mmw" "neo" "6" )
CCSchangeParam( "tcoil" "tcoil_master" "schematic" "tcoil3_mmw" "nei" "5" )
lxGenFromSource( cv_schematic )
cv_layout = dbOpenCellViewByType("tcoil" "tcoil_master" "layout")
MovePinsToInstances( cv_schematic cv_layout )
StreamOutGDS("tcoil" "tcoil_master" "layout" "/autofs/fs1.ece/fs1.eecg.tcc/lizongh2/gf22x-1020b/EMX_work/tcoil_tcoil2746.work" "tcoil2746.gds")

cv_schematic = dbOpenCellViewByType("tcoil" "tcoil_master" "schematic")
CCSchangeParam( "tcoil" "tcoil_master" "schematic" "tcoil3_mmw" "pneo" "60" )
CCSchangeParam( "tcoil" "tcoil_master" "schematic" "tcoil3_mmw" "ctapLocation" "bot" )
CCSchangeParam( "tcoil" "tcoil_master" "schematic" "tcoil3_mmw" "od" "58u" )
CCSchangeParam( "tcoil" "tcoil_master" "schematic" "tcoil3_mmw" "w" "4.2u" )
CCSchangeParam( "tcoil" "tcoil_master" "schematic" "tcoil3_mmw" "neo" "8" )
CCSchangeParam( "tcoil" "tcoil_master" "schematic" "tcoil3_mmw" "nei" "5" )
lxGenFromSource( cv_schematic )
cv_layout = dbOpenCellViewByType("tcoil" "tcoil_master" "layout")
MovePinsToInstances( cv_schematic cv_layout )
StreamOutGDS("tcoil" "tcoil_master" "layout" "/autofs/fs1.ece/fs1.eecg.tcc/lizongh2/gf22x-1020b/EMX_work/tcoil_tcoil2747.work" "tcoil2747.gds")

cv_schematic = dbOpenCellViewByType("tcoil" "tcoil_master" "schematic")
CCSchangeParam( "tcoil" "tcoil_master" "schematic" "tcoil3_mmw" "pneo" "60" )
CCSchangeParam( "tcoil" "tcoil_master" "schematic" "tcoil3_mmw" "ctapLocation" "bot" )
CCSchangeParam( "tcoil" "tcoil_master" "schematic" "tcoil3_mmw" "od" "58u" )
CCSchangeParam( "tcoil" "tcoil_master" "schematic" "tcoil3_mmw" "w" "4.2u" )
CCSchangeParam( "tcoil" "tcoil_master" "schematic" "tcoil3_mmw" "neo" "10" )
CCSchangeParam( "tcoil" "tcoil_master" "schematic" "tcoil3_mmw" "nei" "5" )
lxGenFromSource( cv_schematic )
cv_layout = dbOpenCellViewByType("tcoil" "tcoil_master" "layout")
MovePinsToInstances( cv_schematic cv_layout )
StreamOutGDS("tcoil" "tcoil_master" "layout" "/autofs/fs1.ece/fs1.eecg.tcc/lizongh2/gf22x-1020b/EMX_work/tcoil_tcoil2748.work" "tcoil2748.gds")

cv_schematic = dbOpenCellViewByType("tcoil" "tcoil_master" "schematic")
CCSchangeParam( "tcoil" "tcoil_master" "schematic" "tcoil3_mmw" "pneo" "60" )
CCSchangeParam( "tcoil" "tcoil_master" "schematic" "tcoil3_mmw" "ctapLocation" "bot" )
CCSchangeParam( "tcoil" "tcoil_master" "schematic" "tcoil3_mmw" "od" "58u" )
CCSchangeParam( "tcoil" "tcoil_master" "schematic" "tcoil3_mmw" "w" "4.2u" )
CCSchangeParam( "tcoil" "tcoil_master" "schematic" "tcoil3_mmw" "neo" "12" )
CCSchangeParam( "tcoil" "tcoil_master" "schematic" "tcoil3_mmw" "nei" "5" )
lxGenFromSource( cv_schematic )
cv_layout = dbOpenCellViewByType("tcoil" "tcoil_master" "layout")
MovePinsToInstances( cv_schematic cv_layout )
StreamOutGDS("tcoil" "tcoil_master" "layout" "/autofs/fs1.ece/fs1.eecg.tcc/lizongh2/gf22x-1020b/EMX_work/tcoil_tcoil2749.work" "tcoil2749.gds")

cv_schematic = dbOpenCellViewByType("tcoil" "tcoil_master" "schematic")
CCSchangeParam( "tcoil" "tcoil_master" "schematic" "tcoil3_mmw" "pneo" "60" )
CCSchangeParam( "tcoil" "tcoil_master" "schematic" "tcoil3_mmw" "ctapLocation" "bot" )
CCSchangeParam( "tcoil" "tcoil_master" "schematic" "tcoil3_mmw" "od" "58u" )
CCSchangeParam( "tcoil" "tcoil_master" "schematic" "tcoil3_mmw" "w" "5.0u" )
CCSchangeParam( "tcoil" "tcoil_master" "schematic" "tcoil3_mmw" "neo" "4" )
CCSchangeParam( "tcoil" "tcoil_master" "schematic" "tcoil3_mmw" "nei" "5" )
lxGenFromSource( cv_schematic )
cv_layout = dbOpenCellViewByType("tcoil" "tcoil_master" "layout")
MovePinsToInstances( cv_schematic cv_layout )
StreamOutGDS("tcoil" "tcoil_master" "layout" "/autofs/fs1.ece/fs1.eecg.tcc/lizongh2/gf22x-1020b/EMX_work/tcoil_tcoil2750.work" "tcoil2750.gds")

cv_schematic = dbOpenCellViewByType("tcoil" "tcoil_master" "schematic")
CCSchangeParam( "tcoil" "tcoil_master" "schematic" "tcoil3_mmw" "pneo" "60" )
CCSchangeParam( "tcoil" "tcoil_master" "schematic" "tcoil3_mmw" "ctapLocation" "bot" )
CCSchangeParam( "tcoil" "tcoil_master" "schematic" "tcoil3_mmw" "od" "58u" )
CCSchangeParam( "tcoil" "tcoil_master" "schematic" "tcoil3_mmw" "w" "5.0u" )
CCSchangeParam( "tcoil" "tcoil_master" "schematic" "tcoil3_mmw" "neo" "6" )
CCSchangeParam( "tcoil" "tcoil_master" "schematic" "tcoil3_mmw" "nei" "5" )
lxGenFromSource( cv_schematic )
cv_layout = dbOpenCellViewByType("tcoil" "tcoil_master" "layout")
MovePinsToInstances( cv_schematic cv_layout )
StreamOutGDS("tcoil" "tcoil_master" "layout" "/autofs/fs1.ece/fs1.eecg.tcc/lizongh2/gf22x-1020b/EMX_work/tcoil_tcoil2751.work" "tcoil2751.gds")

cv_schematic = dbOpenCellViewByType("tcoil" "tcoil_master" "schematic")
CCSchangeParam( "tcoil" "tcoil_master" "schematic" "tcoil3_mmw" "pneo" "60" )
CCSchangeParam( "tcoil" "tcoil_master" "schematic" "tcoil3_mmw" "ctapLocation" "bot" )
CCSchangeParam( "tcoil" "tcoil_master" "schematic" "tcoil3_mmw" "od" "58u" )
CCSchangeParam( "tcoil" "tcoil_master" "schematic" "tcoil3_mmw" "w" "5.0u" )
CCSchangeParam( "tcoil" "tcoil_master" "schematic" "tcoil3_mmw" "neo" "8" )
CCSchangeParam( "tcoil" "tcoil_master" "schematic" "tcoil3_mmw" "nei" "5" )
lxGenFromSource( cv_schematic )
cv_layout = dbOpenCellViewByType("tcoil" "tcoil_master" "layout")
MovePinsToInstances( cv_schematic cv_layout )
StreamOutGDS("tcoil" "tcoil_master" "layout" "/autofs/fs1.ece/fs1.eecg.tcc/lizongh2/gf22x-1020b/EMX_work/tcoil_tcoil2752.work" "tcoil2752.gds")

cv_schematic = dbOpenCellViewByType("tcoil" "tcoil_master" "schematic")
CCSchangeParam( "tcoil" "tcoil_master" "schematic" "tcoil3_mmw" "pneo" "60" )
CCSchangeParam( "tcoil" "tcoil_master" "schematic" "tcoil3_mmw" "ctapLocation" "bot" )
CCSchangeParam( "tcoil" "tcoil_master" "schematic" "tcoil3_mmw" "od" "58u" )
CCSchangeParam( "tcoil" "tcoil_master" "schematic" "tcoil3_mmw" "w" "5.0u" )
CCSchangeParam( "tcoil" "tcoil_master" "schematic" "tcoil3_mmw" "neo" "10" )
CCSchangeParam( "tcoil" "tcoil_master" "schematic" "tcoil3_mmw" "nei" "5" )
lxGenFromSource( cv_schematic )
cv_layout = dbOpenCellViewByType("tcoil" "tcoil_master" "layout")
MovePinsToInstances( cv_schematic cv_layout )
StreamOutGDS("tcoil" "tcoil_master" "layout" "/autofs/fs1.ece/fs1.eecg.tcc/lizongh2/gf22x-1020b/EMX_work/tcoil_tcoil2753.work" "tcoil2753.gds")

cv_schematic = dbOpenCellViewByType("tcoil" "tcoil_master" "schematic")
CCSchangeParam( "tcoil" "tcoil_master" "schematic" "tcoil3_mmw" "pneo" "60" )
CCSchangeParam( "tcoil" "tcoil_master" "schematic" "tcoil3_mmw" "ctapLocation" "bot" )
CCSchangeParam( "tcoil" "tcoil_master" "schematic" "tcoil3_mmw" "od" "58u" )
CCSchangeParam( "tcoil" "tcoil_master" "schematic" "tcoil3_mmw" "w" "5.0u" )
CCSchangeParam( "tcoil" "tcoil_master" "schematic" "tcoil3_mmw" "neo" "12" )
CCSchangeParam( "tcoil" "tcoil_master" "schematic" "tcoil3_mmw" "nei" "5" )
lxGenFromSource( cv_schematic )
cv_layout = dbOpenCellViewByType("tcoil" "tcoil_master" "layout")
MovePinsToInstances( cv_schematic cv_layout )
StreamOutGDS("tcoil" "tcoil_master" "layout" "/autofs/fs1.ece/fs1.eecg.tcc/lizongh2/gf22x-1020b/EMX_work/tcoil_tcoil2754.work" "tcoil2754.gds")

cv_schematic = dbOpenCellViewByType("tcoil" "tcoil_master" "schematic")
CCSchangeParam( "tcoil" "tcoil_master" "schematic" "tcoil3_mmw" "pneo" "60" )
CCSchangeParam( "tcoil" "tcoil_master" "schematic" "tcoil3_mmw" "ctapLocation" "bot" )
CCSchangeParam( "tcoil" "tcoil_master" "schematic" "tcoil3_mmw" "od" "60u" )
CCSchangeParam( "tcoil" "tcoil_master" "schematic" "tcoil3_mmw" "w" "2.4u" )
CCSchangeParam( "tcoil" "tcoil_master" "schematic" "tcoil3_mmw" "neo" "4" )
CCSchangeParam( "tcoil" "tcoil_master" "schematic" "tcoil3_mmw" "nei" "5" )
lxGenFromSource( cv_schematic )
cv_layout = dbOpenCellViewByType("tcoil" "tcoil_master" "layout")
MovePinsToInstances( cv_schematic cv_layout )
StreamOutGDS("tcoil" "tcoil_master" "layout" "/autofs/fs1.ece/fs1.eecg.tcc/lizongh2/gf22x-1020b/EMX_work/tcoil_tcoil2755.work" "tcoil2755.gds")

cv_schematic = dbOpenCellViewByType("tcoil" "tcoil_master" "schematic")
CCSchangeParam( "tcoil" "tcoil_master" "schematic" "tcoil3_mmw" "pneo" "60" )
CCSchangeParam( "tcoil" "tcoil_master" "schematic" "tcoil3_mmw" "ctapLocation" "bot" )
CCSchangeParam( "tcoil" "tcoil_master" "schematic" "tcoil3_mmw" "od" "60u" )
CCSchangeParam( "tcoil" "tcoil_master" "schematic" "tcoil3_mmw" "w" "2.4u" )
CCSchangeParam( "tcoil" "tcoil_master" "schematic" "tcoil3_mmw" "neo" "6" )
CCSchangeParam( "tcoil" "tcoil_master" "schematic" "tcoil3_mmw" "nei" "5" )
lxGenFromSource( cv_schematic )
cv_layout = dbOpenCellViewByType("tcoil" "tcoil_master" "layout")
MovePinsToInstances( cv_schematic cv_layout )
StreamOutGDS("tcoil" "tcoil_master" "layout" "/autofs/fs1.ece/fs1.eecg.tcc/lizongh2/gf22x-1020b/EMX_work/tcoil_tcoil2756.work" "tcoil2756.gds")

cv_schematic = dbOpenCellViewByType("tcoil" "tcoil_master" "schematic")
CCSchangeParam( "tcoil" "tcoil_master" "schematic" "tcoil3_mmw" "pneo" "60" )
CCSchangeParam( "tcoil" "tcoil_master" "schematic" "tcoil3_mmw" "ctapLocation" "bot" )
CCSchangeParam( "tcoil" "tcoil_master" "schematic" "tcoil3_mmw" "od" "60u" )
CCSchangeParam( "tcoil" "tcoil_master" "schematic" "tcoil3_mmw" "w" "2.4u" )
CCSchangeParam( "tcoil" "tcoil_master" "schematic" "tcoil3_mmw" "neo" "8" )
CCSchangeParam( "tcoil" "tcoil_master" "schematic" "tcoil3_mmw" "nei" "5" )
lxGenFromSource( cv_schematic )
cv_layout = dbOpenCellViewByType("tcoil" "tcoil_master" "layout")
MovePinsToInstances( cv_schematic cv_layout )
StreamOutGDS("tcoil" "tcoil_master" "layout" "/autofs/fs1.ece/fs1.eecg.tcc/lizongh2/gf22x-1020b/EMX_work/tcoil_tcoil2757.work" "tcoil2757.gds")

cv_schematic = dbOpenCellViewByType("tcoil" "tcoil_master" "schematic")
CCSchangeParam( "tcoil" "tcoil_master" "schematic" "tcoil3_mmw" "pneo" "60" )
CCSchangeParam( "tcoil" "tcoil_master" "schematic" "tcoil3_mmw" "ctapLocation" "bot" )
CCSchangeParam( "tcoil" "tcoil_master" "schematic" "tcoil3_mmw" "od" "60u" )
CCSchangeParam( "tcoil" "tcoil_master" "schematic" "tcoil3_mmw" "w" "2.4u" )
CCSchangeParam( "tcoil" "tcoil_master" "schematic" "tcoil3_mmw" "neo" "10" )
CCSchangeParam( "tcoil" "tcoil_master" "schematic" "tcoil3_mmw" "nei" "5" )
lxGenFromSource( cv_schematic )
cv_layout = dbOpenCellViewByType("tcoil" "tcoil_master" "layout")
MovePinsToInstances( cv_schematic cv_layout )
StreamOutGDS("tcoil" "tcoil_master" "layout" "/autofs/fs1.ece/fs1.eecg.tcc/lizongh2/gf22x-1020b/EMX_work/tcoil_tcoil2758.work" "tcoil2758.gds")

cv_schematic = dbOpenCellViewByType("tcoil" "tcoil_master" "schematic")
CCSchangeParam( "tcoil" "tcoil_master" "schematic" "tcoil3_mmw" "pneo" "60" )
CCSchangeParam( "tcoil" "tcoil_master" "schematic" "tcoil3_mmw" "ctapLocation" "bot" )
CCSchangeParam( "tcoil" "tcoil_master" "schematic" "tcoil3_mmw" "od" "60u" )
CCSchangeParam( "tcoil" "tcoil_master" "schematic" "tcoil3_mmw" "w" "2.4u" )
CCSchangeParam( "tcoil" "tcoil_master" "schematic" "tcoil3_mmw" "neo" "12" )
CCSchangeParam( "tcoil" "tcoil_master" "schematic" "tcoil3_mmw" "nei" "5" )
lxGenFromSource( cv_schematic )
cv_layout = dbOpenCellViewByType("tcoil" "tcoil_master" "layout")
MovePinsToInstances( cv_schematic cv_layout )
StreamOutGDS("tcoil" "tcoil_master" "layout" "/autofs/fs1.ece/fs1.eecg.tcc/lizongh2/gf22x-1020b/EMX_work/tcoil_tcoil2759.work" "tcoil2759.gds")

cv_schematic = dbOpenCellViewByType("tcoil" "tcoil_master" "schematic")
CCSchangeParam( "tcoil" "tcoil_master" "schematic" "tcoil3_mmw" "pneo" "60" )
CCSchangeParam( "tcoil" "tcoil_master" "schematic" "tcoil3_mmw" "ctapLocation" "bot" )
CCSchangeParam( "tcoil" "tcoil_master" "schematic" "tcoil3_mmw" "od" "60u" )
CCSchangeParam( "tcoil" "tcoil_master" "schematic" "tcoil3_mmw" "w" "4.2u" )
CCSchangeParam( "tcoil" "tcoil_master" "schematic" "tcoil3_mmw" "neo" "4" )
CCSchangeParam( "tcoil" "tcoil_master" "schematic" "tcoil3_mmw" "nei" "5" )
lxGenFromSource( cv_schematic )
cv_layout = dbOpenCellViewByType("tcoil" "tcoil_master" "layout")
MovePinsToInstances( cv_schematic cv_layout )
StreamOutGDS("tcoil" "tcoil_master" "layout" "/autofs/fs1.ece/fs1.eecg.tcc/lizongh2/gf22x-1020b/EMX_work/tcoil_tcoil2760.work" "tcoil2760.gds")

cv_schematic = dbOpenCellViewByType("tcoil" "tcoil_master" "schematic")
CCSchangeParam( "tcoil" "tcoil_master" "schematic" "tcoil3_mmw" "pneo" "60" )
CCSchangeParam( "tcoil" "tcoil_master" "schematic" "tcoil3_mmw" "ctapLocation" "bot" )
CCSchangeParam( "tcoil" "tcoil_master" "schematic" "tcoil3_mmw" "od" "60u" )
CCSchangeParam( "tcoil" "tcoil_master" "schematic" "tcoil3_mmw" "w" "4.2u" )
CCSchangeParam( "tcoil" "tcoil_master" "schematic" "tcoil3_mmw" "neo" "6" )
CCSchangeParam( "tcoil" "tcoil_master" "schematic" "tcoil3_mmw" "nei" "5" )
lxGenFromSource( cv_schematic )
cv_layout = dbOpenCellViewByType("tcoil" "tcoil_master" "layout")
MovePinsToInstances( cv_schematic cv_layout )
StreamOutGDS("tcoil" "tcoil_master" "layout" "/autofs/fs1.ece/fs1.eecg.tcc/lizongh2/gf22x-1020b/EMX_work/tcoil_tcoil2761.work" "tcoil2761.gds")

cv_schematic = dbOpenCellViewByType("tcoil" "tcoil_master" "schematic")
CCSchangeParam( "tcoil" "tcoil_master" "schematic" "tcoil3_mmw" "pneo" "60" )
CCSchangeParam( "tcoil" "tcoil_master" "schematic" "tcoil3_mmw" "ctapLocation" "bot" )
CCSchangeParam( "tcoil" "tcoil_master" "schematic" "tcoil3_mmw" "od" "60u" )
CCSchangeParam( "tcoil" "tcoil_master" "schematic" "tcoil3_mmw" "w" "4.2u" )
CCSchangeParam( "tcoil" "tcoil_master" "schematic" "tcoil3_mmw" "neo" "8" )
CCSchangeParam( "tcoil" "tcoil_master" "schematic" "tcoil3_mmw" "nei" "5" )
lxGenFromSource( cv_schematic )
cv_layout = dbOpenCellViewByType("tcoil" "tcoil_master" "layout")
MovePinsToInstances( cv_schematic cv_layout )
StreamOutGDS("tcoil" "tcoil_master" "layout" "/autofs/fs1.ece/fs1.eecg.tcc/lizongh2/gf22x-1020b/EMX_work/tcoil_tcoil2762.work" "tcoil2762.gds")

cv_schematic = dbOpenCellViewByType("tcoil" "tcoil_master" "schematic")
CCSchangeParam( "tcoil" "tcoil_master" "schematic" "tcoil3_mmw" "pneo" "60" )
CCSchangeParam( "tcoil" "tcoil_master" "schematic" "tcoil3_mmw" "ctapLocation" "bot" )
CCSchangeParam( "tcoil" "tcoil_master" "schematic" "tcoil3_mmw" "od" "60u" )
CCSchangeParam( "tcoil" "tcoil_master" "schematic" "tcoil3_mmw" "w" "4.2u" )
CCSchangeParam( "tcoil" "tcoil_master" "schematic" "tcoil3_mmw" "neo" "10" )
CCSchangeParam( "tcoil" "tcoil_master" "schematic" "tcoil3_mmw" "nei" "5" )
lxGenFromSource( cv_schematic )
cv_layout = dbOpenCellViewByType("tcoil" "tcoil_master" "layout")
MovePinsToInstances( cv_schematic cv_layout )
StreamOutGDS("tcoil" "tcoil_master" "layout" "/autofs/fs1.ece/fs1.eecg.tcc/lizongh2/gf22x-1020b/EMX_work/tcoil_tcoil2763.work" "tcoil2763.gds")

cv_schematic = dbOpenCellViewByType("tcoil" "tcoil_master" "schematic")
CCSchangeParam( "tcoil" "tcoil_master" "schematic" "tcoil3_mmw" "pneo" "60" )
CCSchangeParam( "tcoil" "tcoil_master" "schematic" "tcoil3_mmw" "ctapLocation" "bot" )
CCSchangeParam( "tcoil" "tcoil_master" "schematic" "tcoil3_mmw" "od" "60u" )
CCSchangeParam( "tcoil" "tcoil_master" "schematic" "tcoil3_mmw" "w" "4.2u" )
CCSchangeParam( "tcoil" "tcoil_master" "schematic" "tcoil3_mmw" "neo" "12" )
CCSchangeParam( "tcoil" "tcoil_master" "schematic" "tcoil3_mmw" "nei" "5" )
lxGenFromSource( cv_schematic )
cv_layout = dbOpenCellViewByType("tcoil" "tcoil_master" "layout")
MovePinsToInstances( cv_schematic cv_layout )
StreamOutGDS("tcoil" "tcoil_master" "layout" "/autofs/fs1.ece/fs1.eecg.tcc/lizongh2/gf22x-1020b/EMX_work/tcoil_tcoil2764.work" "tcoil2764.gds")

cv_schematic = dbOpenCellViewByType("tcoil" "tcoil_master" "schematic")
CCSchangeParam( "tcoil" "tcoil_master" "schematic" "tcoil3_mmw" "pneo" "60" )
CCSchangeParam( "tcoil" "tcoil_master" "schematic" "tcoil3_mmw" "ctapLocation" "bot" )
CCSchangeParam( "tcoil" "tcoil_master" "schematic" "tcoil3_mmw" "od" "60u" )
CCSchangeParam( "tcoil" "tcoil_master" "schematic" "tcoil3_mmw" "w" "5.0u" )
CCSchangeParam( "tcoil" "tcoil_master" "schematic" "tcoil3_mmw" "neo" "4" )
CCSchangeParam( "tcoil" "tcoil_master" "schematic" "tcoil3_mmw" "nei" "5" )
lxGenFromSource( cv_schematic )
cv_layout = dbOpenCellViewByType("tcoil" "tcoil_master" "layout")
MovePinsToInstances( cv_schematic cv_layout )
StreamOutGDS("tcoil" "tcoil_master" "layout" "/autofs/fs1.ece/fs1.eecg.tcc/lizongh2/gf22x-1020b/EMX_work/tcoil_tcoil2765.work" "tcoil2765.gds")

cv_schematic = dbOpenCellViewByType("tcoil" "tcoil_master" "schematic")
CCSchangeParam( "tcoil" "tcoil_master" "schematic" "tcoil3_mmw" "pneo" "60" )
CCSchangeParam( "tcoil" "tcoil_master" "schematic" "tcoil3_mmw" "ctapLocation" "bot" )
CCSchangeParam( "tcoil" "tcoil_master" "schematic" "tcoil3_mmw" "od" "60u" )
CCSchangeParam( "tcoil" "tcoil_master" "schematic" "tcoil3_mmw" "w" "5.0u" )
CCSchangeParam( "tcoil" "tcoil_master" "schematic" "tcoil3_mmw" "neo" "6" )
CCSchangeParam( "tcoil" "tcoil_master" "schematic" "tcoil3_mmw" "nei" "5" )
lxGenFromSource( cv_schematic )
cv_layout = dbOpenCellViewByType("tcoil" "tcoil_master" "layout")
MovePinsToInstances( cv_schematic cv_layout )
StreamOutGDS("tcoil" "tcoil_master" "layout" "/autofs/fs1.ece/fs1.eecg.tcc/lizongh2/gf22x-1020b/EMX_work/tcoil_tcoil2766.work" "tcoil2766.gds")

cv_schematic = dbOpenCellViewByType("tcoil" "tcoil_master" "schematic")
CCSchangeParam( "tcoil" "tcoil_master" "schematic" "tcoil3_mmw" "pneo" "60" )
CCSchangeParam( "tcoil" "tcoil_master" "schematic" "tcoil3_mmw" "ctapLocation" "bot" )
CCSchangeParam( "tcoil" "tcoil_master" "schematic" "tcoil3_mmw" "od" "60u" )
CCSchangeParam( "tcoil" "tcoil_master" "schematic" "tcoil3_mmw" "w" "5.0u" )
CCSchangeParam( "tcoil" "tcoil_master" "schematic" "tcoil3_mmw" "neo" "8" )
CCSchangeParam( "tcoil" "tcoil_master" "schematic" "tcoil3_mmw" "nei" "5" )
lxGenFromSource( cv_schematic )
cv_layout = dbOpenCellViewByType("tcoil" "tcoil_master" "layout")
MovePinsToInstances( cv_schematic cv_layout )
StreamOutGDS("tcoil" "tcoil_master" "layout" "/autofs/fs1.ece/fs1.eecg.tcc/lizongh2/gf22x-1020b/EMX_work/tcoil_tcoil2767.work" "tcoil2767.gds")

cv_schematic = dbOpenCellViewByType("tcoil" "tcoil_master" "schematic")
CCSchangeParam( "tcoil" "tcoil_master" "schematic" "tcoil3_mmw" "pneo" "60" )
CCSchangeParam( "tcoil" "tcoil_master" "schematic" "tcoil3_mmw" "ctapLocation" "bot" )
CCSchangeParam( "tcoil" "tcoil_master" "schematic" "tcoil3_mmw" "od" "60u" )
CCSchangeParam( "tcoil" "tcoil_master" "schematic" "tcoil3_mmw" "w" "5.0u" )
CCSchangeParam( "tcoil" "tcoil_master" "schematic" "tcoil3_mmw" "neo" "10" )
CCSchangeParam( "tcoil" "tcoil_master" "schematic" "tcoil3_mmw" "nei" "5" )
lxGenFromSource( cv_schematic )
cv_layout = dbOpenCellViewByType("tcoil" "tcoil_master" "layout")
MovePinsToInstances( cv_schematic cv_layout )
StreamOutGDS("tcoil" "tcoil_master" "layout" "/autofs/fs1.ece/fs1.eecg.tcc/lizongh2/gf22x-1020b/EMX_work/tcoil_tcoil2768.work" "tcoil2768.gds")

cv_schematic = dbOpenCellViewByType("tcoil" "tcoil_master" "schematic")
CCSchangeParam( "tcoil" "tcoil_master" "schematic" "tcoil3_mmw" "pneo" "60" )
CCSchangeParam( "tcoil" "tcoil_master" "schematic" "tcoil3_mmw" "ctapLocation" "bot" )
CCSchangeParam( "tcoil" "tcoil_master" "schematic" "tcoil3_mmw" "od" "60u" )
CCSchangeParam( "tcoil" "tcoil_master" "schematic" "tcoil3_mmw" "w" "5.0u" )
CCSchangeParam( "tcoil" "tcoil_master" "schematic" "tcoil3_mmw" "neo" "12" )
CCSchangeParam( "tcoil" "tcoil_master" "schematic" "tcoil3_mmw" "nei" "5" )
lxGenFromSource( cv_schematic )
cv_layout = dbOpenCellViewByType("tcoil" "tcoil_master" "layout")
MovePinsToInstances( cv_schematic cv_layout )
StreamOutGDS("tcoil" "tcoil_master" "layout" "/autofs/fs1.ece/fs1.eecg.tcc/lizongh2/gf22x-1020b/EMX_work/tcoil_tcoil2769.work" "tcoil2769.gds")

cv_schematic = dbOpenCellViewByType("tcoil" "tcoil_master" "schematic")
CCSchangeParam( "tcoil" "tcoil_master" "schematic" "tcoil3_mmw" "pneo" "60" )
CCSchangeParam( "tcoil" "tcoil_master" "schematic" "tcoil3_mmw" "ctapLocation" "bot" )
CCSchangeParam( "tcoil" "tcoil_master" "schematic" "tcoil3_mmw" "od" "62u" )
CCSchangeParam( "tcoil" "tcoil_master" "schematic" "tcoil3_mmw" "w" "2.4u" )
CCSchangeParam( "tcoil" "tcoil_master" "schematic" "tcoil3_mmw" "neo" "4" )
CCSchangeParam( "tcoil" "tcoil_master" "schematic" "tcoil3_mmw" "nei" "5" )
lxGenFromSource( cv_schematic )
cv_layout = dbOpenCellViewByType("tcoil" "tcoil_master" "layout")
MovePinsToInstances( cv_schematic cv_layout )
StreamOutGDS("tcoil" "tcoil_master" "layout" "/autofs/fs1.ece/fs1.eecg.tcc/lizongh2/gf22x-1020b/EMX_work/tcoil_tcoil2770.work" "tcoil2770.gds")

cv_schematic = dbOpenCellViewByType("tcoil" "tcoil_master" "schematic")
CCSchangeParam( "tcoil" "tcoil_master" "schematic" "tcoil3_mmw" "pneo" "60" )
CCSchangeParam( "tcoil" "tcoil_master" "schematic" "tcoil3_mmw" "ctapLocation" "bot" )
CCSchangeParam( "tcoil" "tcoil_master" "schematic" "tcoil3_mmw" "od" "62u" )
CCSchangeParam( "tcoil" "tcoil_master" "schematic" "tcoil3_mmw" "w" "2.4u" )
CCSchangeParam( "tcoil" "tcoil_master" "schematic" "tcoil3_mmw" "neo" "6" )
CCSchangeParam( "tcoil" "tcoil_master" "schematic" "tcoil3_mmw" "nei" "5" )
lxGenFromSource( cv_schematic )
cv_layout = dbOpenCellViewByType("tcoil" "tcoil_master" "layout")
MovePinsToInstances( cv_schematic cv_layout )
StreamOutGDS("tcoil" "tcoil_master" "layout" "/autofs/fs1.ece/fs1.eecg.tcc/lizongh2/gf22x-1020b/EMX_work/tcoil_tcoil2771.work" "tcoil2771.gds")

cv_schematic = dbOpenCellViewByType("tcoil" "tcoil_master" "schematic")
CCSchangeParam( "tcoil" "tcoil_master" "schematic" "tcoil3_mmw" "pneo" "60" )
CCSchangeParam( "tcoil" "tcoil_master" "schematic" "tcoil3_mmw" "ctapLocation" "bot" )
CCSchangeParam( "tcoil" "tcoil_master" "schematic" "tcoil3_mmw" "od" "62u" )
CCSchangeParam( "tcoil" "tcoil_master" "schematic" "tcoil3_mmw" "w" "2.4u" )
CCSchangeParam( "tcoil" "tcoil_master" "schematic" "tcoil3_mmw" "neo" "8" )
CCSchangeParam( "tcoil" "tcoil_master" "schematic" "tcoil3_mmw" "nei" "5" )
lxGenFromSource( cv_schematic )
cv_layout = dbOpenCellViewByType("tcoil" "tcoil_master" "layout")
MovePinsToInstances( cv_schematic cv_layout )
StreamOutGDS("tcoil" "tcoil_master" "layout" "/autofs/fs1.ece/fs1.eecg.tcc/lizongh2/gf22x-1020b/EMX_work/tcoil_tcoil2772.work" "tcoil2772.gds")

cv_schematic = dbOpenCellViewByType("tcoil" "tcoil_master" "schematic")
CCSchangeParam( "tcoil" "tcoil_master" "schematic" "tcoil3_mmw" "pneo" "60" )
CCSchangeParam( "tcoil" "tcoil_master" "schematic" "tcoil3_mmw" "ctapLocation" "bot" )
CCSchangeParam( "tcoil" "tcoil_master" "schematic" "tcoil3_mmw" "od" "62u" )
CCSchangeParam( "tcoil" "tcoil_master" "schematic" "tcoil3_mmw" "w" "2.4u" )
CCSchangeParam( "tcoil" "tcoil_master" "schematic" "tcoil3_mmw" "neo" "10" )
CCSchangeParam( "tcoil" "tcoil_master" "schematic" "tcoil3_mmw" "nei" "5" )
lxGenFromSource( cv_schematic )
cv_layout = dbOpenCellViewByType("tcoil" "tcoil_master" "layout")
MovePinsToInstances( cv_schematic cv_layout )
StreamOutGDS("tcoil" "tcoil_master" "layout" "/autofs/fs1.ece/fs1.eecg.tcc/lizongh2/gf22x-1020b/EMX_work/tcoil_tcoil2773.work" "tcoil2773.gds")

cv_schematic = dbOpenCellViewByType("tcoil" "tcoil_master" "schematic")
CCSchangeParam( "tcoil" "tcoil_master" "schematic" "tcoil3_mmw" "pneo" "60" )
CCSchangeParam( "tcoil" "tcoil_master" "schematic" "tcoil3_mmw" "ctapLocation" "bot" )
CCSchangeParam( "tcoil" "tcoil_master" "schematic" "tcoil3_mmw" "od" "62u" )
CCSchangeParam( "tcoil" "tcoil_master" "schematic" "tcoil3_mmw" "w" "2.4u" )
CCSchangeParam( "tcoil" "tcoil_master" "schematic" "tcoil3_mmw" "neo" "12" )
CCSchangeParam( "tcoil" "tcoil_master" "schematic" "tcoil3_mmw" "nei" "5" )
lxGenFromSource( cv_schematic )
cv_layout = dbOpenCellViewByType("tcoil" "tcoil_master" "layout")
MovePinsToInstances( cv_schematic cv_layout )
StreamOutGDS("tcoil" "tcoil_master" "layout" "/autofs/fs1.ece/fs1.eecg.tcc/lizongh2/gf22x-1020b/EMX_work/tcoil_tcoil2774.work" "tcoil2774.gds")

cv_schematic = dbOpenCellViewByType("tcoil" "tcoil_master" "schematic")
CCSchangeParam( "tcoil" "tcoil_master" "schematic" "tcoil3_mmw" "pneo" "60" )
CCSchangeParam( "tcoil" "tcoil_master" "schematic" "tcoil3_mmw" "ctapLocation" "bot" )
CCSchangeParam( "tcoil" "tcoil_master" "schematic" "tcoil3_mmw" "od" "62u" )
CCSchangeParam( "tcoil" "tcoil_master" "schematic" "tcoil3_mmw" "w" "4.2u" )
CCSchangeParam( "tcoil" "tcoil_master" "schematic" "tcoil3_mmw" "neo" "4" )
CCSchangeParam( "tcoil" "tcoil_master" "schematic" "tcoil3_mmw" "nei" "5" )
lxGenFromSource( cv_schematic )
cv_layout = dbOpenCellViewByType("tcoil" "tcoil_master" "layout")
MovePinsToInstances( cv_schematic cv_layout )
StreamOutGDS("tcoil" "tcoil_master" "layout" "/autofs/fs1.ece/fs1.eecg.tcc/lizongh2/gf22x-1020b/EMX_work/tcoil_tcoil2775.work" "tcoil2775.gds")

cv_schematic = dbOpenCellViewByType("tcoil" "tcoil_master" "schematic")
CCSchangeParam( "tcoil" "tcoil_master" "schematic" "tcoil3_mmw" "pneo" "60" )
CCSchangeParam( "tcoil" "tcoil_master" "schematic" "tcoil3_mmw" "ctapLocation" "bot" )
CCSchangeParam( "tcoil" "tcoil_master" "schematic" "tcoil3_mmw" "od" "62u" )
CCSchangeParam( "tcoil" "tcoil_master" "schematic" "tcoil3_mmw" "w" "4.2u" )
CCSchangeParam( "tcoil" "tcoil_master" "schematic" "tcoil3_mmw" "neo" "6" )
CCSchangeParam( "tcoil" "tcoil_master" "schematic" "tcoil3_mmw" "nei" "5" )
lxGenFromSource( cv_schematic )
cv_layout = dbOpenCellViewByType("tcoil" "tcoil_master" "layout")
MovePinsToInstances( cv_schematic cv_layout )
StreamOutGDS("tcoil" "tcoil_master" "layout" "/autofs/fs1.ece/fs1.eecg.tcc/lizongh2/gf22x-1020b/EMX_work/tcoil_tcoil2776.work" "tcoil2776.gds")

cv_schematic = dbOpenCellViewByType("tcoil" "tcoil_master" "schematic")
CCSchangeParam( "tcoil" "tcoil_master" "schematic" "tcoil3_mmw" "pneo" "60" )
CCSchangeParam( "tcoil" "tcoil_master" "schematic" "tcoil3_mmw" "ctapLocation" "bot" )
CCSchangeParam( "tcoil" "tcoil_master" "schematic" "tcoil3_mmw" "od" "62u" )
CCSchangeParam( "tcoil" "tcoil_master" "schematic" "tcoil3_mmw" "w" "4.2u" )
CCSchangeParam( "tcoil" "tcoil_master" "schematic" "tcoil3_mmw" "neo" "8" )
CCSchangeParam( "tcoil" "tcoil_master" "schematic" "tcoil3_mmw" "nei" "5" )
lxGenFromSource( cv_schematic )
cv_layout = dbOpenCellViewByType("tcoil" "tcoil_master" "layout")
MovePinsToInstances( cv_schematic cv_layout )
StreamOutGDS("tcoil" "tcoil_master" "layout" "/autofs/fs1.ece/fs1.eecg.tcc/lizongh2/gf22x-1020b/EMX_work/tcoil_tcoil2777.work" "tcoil2777.gds")

cv_schematic = dbOpenCellViewByType("tcoil" "tcoil_master" "schematic")
CCSchangeParam( "tcoil" "tcoil_master" "schematic" "tcoil3_mmw" "pneo" "60" )
CCSchangeParam( "tcoil" "tcoil_master" "schematic" "tcoil3_mmw" "ctapLocation" "bot" )
CCSchangeParam( "tcoil" "tcoil_master" "schematic" "tcoil3_mmw" "od" "62u" )
CCSchangeParam( "tcoil" "tcoil_master" "schematic" "tcoil3_mmw" "w" "4.2u" )
CCSchangeParam( "tcoil" "tcoil_master" "schematic" "tcoil3_mmw" "neo" "10" )
CCSchangeParam( "tcoil" "tcoil_master" "schematic" "tcoil3_mmw" "nei" "5" )
lxGenFromSource( cv_schematic )
cv_layout = dbOpenCellViewByType("tcoil" "tcoil_master" "layout")
MovePinsToInstances( cv_schematic cv_layout )
StreamOutGDS("tcoil" "tcoil_master" "layout" "/autofs/fs1.ece/fs1.eecg.tcc/lizongh2/gf22x-1020b/EMX_work/tcoil_tcoil2778.work" "tcoil2778.gds")

cv_schematic = dbOpenCellViewByType("tcoil" "tcoil_master" "schematic")
CCSchangeParam( "tcoil" "tcoil_master" "schematic" "tcoil3_mmw" "pneo" "60" )
CCSchangeParam( "tcoil" "tcoil_master" "schematic" "tcoil3_mmw" "ctapLocation" "bot" )
CCSchangeParam( "tcoil" "tcoil_master" "schematic" "tcoil3_mmw" "od" "62u" )
CCSchangeParam( "tcoil" "tcoil_master" "schematic" "tcoil3_mmw" "w" "4.2u" )
CCSchangeParam( "tcoil" "tcoil_master" "schematic" "tcoil3_mmw" "neo" "12" )
CCSchangeParam( "tcoil" "tcoil_master" "schematic" "tcoil3_mmw" "nei" "5" )
lxGenFromSource( cv_schematic )
cv_layout = dbOpenCellViewByType("tcoil" "tcoil_master" "layout")
MovePinsToInstances( cv_schematic cv_layout )
StreamOutGDS("tcoil" "tcoil_master" "layout" "/autofs/fs1.ece/fs1.eecg.tcc/lizongh2/gf22x-1020b/EMX_work/tcoil_tcoil2779.work" "tcoil2779.gds")

cv_schematic = dbOpenCellViewByType("tcoil" "tcoil_master" "schematic")
CCSchangeParam( "tcoil" "tcoil_master" "schematic" "tcoil3_mmw" "pneo" "60" )
CCSchangeParam( "tcoil" "tcoil_master" "schematic" "tcoil3_mmw" "ctapLocation" "bot" )
CCSchangeParam( "tcoil" "tcoil_master" "schematic" "tcoil3_mmw" "od" "62u" )
CCSchangeParam( "tcoil" "tcoil_master" "schematic" "tcoil3_mmw" "w" "5.0u" )
CCSchangeParam( "tcoil" "tcoil_master" "schematic" "tcoil3_mmw" "neo" "4" )
CCSchangeParam( "tcoil" "tcoil_master" "schematic" "tcoil3_mmw" "nei" "5" )
lxGenFromSource( cv_schematic )
cv_layout = dbOpenCellViewByType("tcoil" "tcoil_master" "layout")
MovePinsToInstances( cv_schematic cv_layout )
StreamOutGDS("tcoil" "tcoil_master" "layout" "/autofs/fs1.ece/fs1.eecg.tcc/lizongh2/gf22x-1020b/EMX_work/tcoil_tcoil2780.work" "tcoil2780.gds")

cv_schematic = dbOpenCellViewByType("tcoil" "tcoil_master" "schematic")
CCSchangeParam( "tcoil" "tcoil_master" "schematic" "tcoil3_mmw" "pneo" "60" )
CCSchangeParam( "tcoil" "tcoil_master" "schematic" "tcoil3_mmw" "ctapLocation" "bot" )
CCSchangeParam( "tcoil" "tcoil_master" "schematic" "tcoil3_mmw" "od" "62u" )
CCSchangeParam( "tcoil" "tcoil_master" "schematic" "tcoil3_mmw" "w" "5.0u" )
CCSchangeParam( "tcoil" "tcoil_master" "schematic" "tcoil3_mmw" "neo" "6" )
CCSchangeParam( "tcoil" "tcoil_master" "schematic" "tcoil3_mmw" "nei" "5" )
lxGenFromSource( cv_schematic )
cv_layout = dbOpenCellViewByType("tcoil" "tcoil_master" "layout")
MovePinsToInstances( cv_schematic cv_layout )
StreamOutGDS("tcoil" "tcoil_master" "layout" "/autofs/fs1.ece/fs1.eecg.tcc/lizongh2/gf22x-1020b/EMX_work/tcoil_tcoil2781.work" "tcoil2781.gds")

cv_schematic = dbOpenCellViewByType("tcoil" "tcoil_master" "schematic")
CCSchangeParam( "tcoil" "tcoil_master" "schematic" "tcoil3_mmw" "pneo" "60" )
CCSchangeParam( "tcoil" "tcoil_master" "schematic" "tcoil3_mmw" "ctapLocation" "bot" )
CCSchangeParam( "tcoil" "tcoil_master" "schematic" "tcoil3_mmw" "od" "62u" )
CCSchangeParam( "tcoil" "tcoil_master" "schematic" "tcoil3_mmw" "w" "5.0u" )
CCSchangeParam( "tcoil" "tcoil_master" "schematic" "tcoil3_mmw" "neo" "8" )
CCSchangeParam( "tcoil" "tcoil_master" "schematic" "tcoil3_mmw" "nei" "5" )
lxGenFromSource( cv_schematic )
cv_layout = dbOpenCellViewByType("tcoil" "tcoil_master" "layout")
MovePinsToInstances( cv_schematic cv_layout )
StreamOutGDS("tcoil" "tcoil_master" "layout" "/autofs/fs1.ece/fs1.eecg.tcc/lizongh2/gf22x-1020b/EMX_work/tcoil_tcoil2782.work" "tcoil2782.gds")

cv_schematic = dbOpenCellViewByType("tcoil" "tcoil_master" "schematic")
CCSchangeParam( "tcoil" "tcoil_master" "schematic" "tcoil3_mmw" "pneo" "60" )
CCSchangeParam( "tcoil" "tcoil_master" "schematic" "tcoil3_mmw" "ctapLocation" "bot" )
CCSchangeParam( "tcoil" "tcoil_master" "schematic" "tcoil3_mmw" "od" "62u" )
CCSchangeParam( "tcoil" "tcoil_master" "schematic" "tcoil3_mmw" "w" "5.0u" )
CCSchangeParam( "tcoil" "tcoil_master" "schematic" "tcoil3_mmw" "neo" "10" )
CCSchangeParam( "tcoil" "tcoil_master" "schematic" "tcoil3_mmw" "nei" "5" )
lxGenFromSource( cv_schematic )
cv_layout = dbOpenCellViewByType("tcoil" "tcoil_master" "layout")
MovePinsToInstances( cv_schematic cv_layout )
StreamOutGDS("tcoil" "tcoil_master" "layout" "/autofs/fs1.ece/fs1.eecg.tcc/lizongh2/gf22x-1020b/EMX_work/tcoil_tcoil2783.work" "tcoil2783.gds")

cv_schematic = dbOpenCellViewByType("tcoil" "tcoil_master" "schematic")
CCSchangeParam( "tcoil" "tcoil_master" "schematic" "tcoil3_mmw" "pneo" "60" )
CCSchangeParam( "tcoil" "tcoil_master" "schematic" "tcoil3_mmw" "ctapLocation" "bot" )
CCSchangeParam( "tcoil" "tcoil_master" "schematic" "tcoil3_mmw" "od" "62u" )
CCSchangeParam( "tcoil" "tcoil_master" "schematic" "tcoil3_mmw" "w" "5.0u" )
CCSchangeParam( "tcoil" "tcoil_master" "schematic" "tcoil3_mmw" "neo" "12" )
CCSchangeParam( "tcoil" "tcoil_master" "schematic" "tcoil3_mmw" "nei" "5" )
lxGenFromSource( cv_schematic )
cv_layout = dbOpenCellViewByType("tcoil" "tcoil_master" "layout")
MovePinsToInstances( cv_schematic cv_layout )
StreamOutGDS("tcoil" "tcoil_master" "layout" "/autofs/fs1.ece/fs1.eecg.tcc/lizongh2/gf22x-1020b/EMX_work/tcoil_tcoil2784.work" "tcoil2784.gds")

cv_schematic = dbOpenCellViewByType("tcoil" "tcoil_master" "schematic")
CCSchangeParam( "tcoil" "tcoil_master" "schematic" "tcoil3_mmw" "pneo" "60" )
CCSchangeParam( "tcoil" "tcoil_master" "schematic" "tcoil3_mmw" "ctapLocation" "bot" )
CCSchangeParam( "tcoil" "tcoil_master" "schematic" "tcoil3_mmw" "od" "64u" )
CCSchangeParam( "tcoil" "tcoil_master" "schematic" "tcoil3_mmw" "w" "2.4u" )
CCSchangeParam( "tcoil" "tcoil_master" "schematic" "tcoil3_mmw" "neo" "4" )
CCSchangeParam( "tcoil" "tcoil_master" "schematic" "tcoil3_mmw" "nei" "5" )
lxGenFromSource( cv_schematic )
cv_layout = dbOpenCellViewByType("tcoil" "tcoil_master" "layout")
MovePinsToInstances( cv_schematic cv_layout )
StreamOutGDS("tcoil" "tcoil_master" "layout" "/autofs/fs1.ece/fs1.eecg.tcc/lizongh2/gf22x-1020b/EMX_work/tcoil_tcoil2785.work" "tcoil2785.gds")

cv_schematic = dbOpenCellViewByType("tcoil" "tcoil_master" "schematic")
CCSchangeParam( "tcoil" "tcoil_master" "schematic" "tcoil3_mmw" "pneo" "60" )
CCSchangeParam( "tcoil" "tcoil_master" "schematic" "tcoil3_mmw" "ctapLocation" "bot" )
CCSchangeParam( "tcoil" "tcoil_master" "schematic" "tcoil3_mmw" "od" "64u" )
CCSchangeParam( "tcoil" "tcoil_master" "schematic" "tcoil3_mmw" "w" "2.4u" )
CCSchangeParam( "tcoil" "tcoil_master" "schematic" "tcoil3_mmw" "neo" "6" )
CCSchangeParam( "tcoil" "tcoil_master" "schematic" "tcoil3_mmw" "nei" "5" )
lxGenFromSource( cv_schematic )
cv_layout = dbOpenCellViewByType("tcoil" "tcoil_master" "layout")
MovePinsToInstances( cv_schematic cv_layout )
StreamOutGDS("tcoil" "tcoil_master" "layout" "/autofs/fs1.ece/fs1.eecg.tcc/lizongh2/gf22x-1020b/EMX_work/tcoil_tcoil2786.work" "tcoil2786.gds")

cv_schematic = dbOpenCellViewByType("tcoil" "tcoil_master" "schematic")
CCSchangeParam( "tcoil" "tcoil_master" "schematic" "tcoil3_mmw" "pneo" "60" )
CCSchangeParam( "tcoil" "tcoil_master" "schematic" "tcoil3_mmw" "ctapLocation" "bot" )
CCSchangeParam( "tcoil" "tcoil_master" "schematic" "tcoil3_mmw" "od" "64u" )
CCSchangeParam( "tcoil" "tcoil_master" "schematic" "tcoil3_mmw" "w" "2.4u" )
CCSchangeParam( "tcoil" "tcoil_master" "schematic" "tcoil3_mmw" "neo" "8" )
CCSchangeParam( "tcoil" "tcoil_master" "schematic" "tcoil3_mmw" "nei" "5" )
lxGenFromSource( cv_schematic )
cv_layout = dbOpenCellViewByType("tcoil" "tcoil_master" "layout")
MovePinsToInstances( cv_schematic cv_layout )
StreamOutGDS("tcoil" "tcoil_master" "layout" "/autofs/fs1.ece/fs1.eecg.tcc/lizongh2/gf22x-1020b/EMX_work/tcoil_tcoil2787.work" "tcoil2787.gds")

cv_schematic = dbOpenCellViewByType("tcoil" "tcoil_master" "schematic")
CCSchangeParam( "tcoil" "tcoil_master" "schematic" "tcoil3_mmw" "pneo" "60" )
CCSchangeParam( "tcoil" "tcoil_master" "schematic" "tcoil3_mmw" "ctapLocation" "bot" )
CCSchangeParam( "tcoil" "tcoil_master" "schematic" "tcoil3_mmw" "od" "64u" )
CCSchangeParam( "tcoil" "tcoil_master" "schematic" "tcoil3_mmw" "w" "2.4u" )
CCSchangeParam( "tcoil" "tcoil_master" "schematic" "tcoil3_mmw" "neo" "10" )
CCSchangeParam( "tcoil" "tcoil_master" "schematic" "tcoil3_mmw" "nei" "5" )
lxGenFromSource( cv_schematic )
cv_layout = dbOpenCellViewByType("tcoil" "tcoil_master" "layout")
MovePinsToInstances( cv_schematic cv_layout )
StreamOutGDS("tcoil" "tcoil_master" "layout" "/autofs/fs1.ece/fs1.eecg.tcc/lizongh2/gf22x-1020b/EMX_work/tcoil_tcoil2788.work" "tcoil2788.gds")

cv_schematic = dbOpenCellViewByType("tcoil" "tcoil_master" "schematic")
CCSchangeParam( "tcoil" "tcoil_master" "schematic" "tcoil3_mmw" "pneo" "60" )
CCSchangeParam( "tcoil" "tcoil_master" "schematic" "tcoil3_mmw" "ctapLocation" "bot" )
CCSchangeParam( "tcoil" "tcoil_master" "schematic" "tcoil3_mmw" "od" "64u" )
CCSchangeParam( "tcoil" "tcoil_master" "schematic" "tcoil3_mmw" "w" "2.4u" )
CCSchangeParam( "tcoil" "tcoil_master" "schematic" "tcoil3_mmw" "neo" "12" )
CCSchangeParam( "tcoil" "tcoil_master" "schematic" "tcoil3_mmw" "nei" "5" )
lxGenFromSource( cv_schematic )
cv_layout = dbOpenCellViewByType("tcoil" "tcoil_master" "layout")
MovePinsToInstances( cv_schematic cv_layout )
StreamOutGDS("tcoil" "tcoil_master" "layout" "/autofs/fs1.ece/fs1.eecg.tcc/lizongh2/gf22x-1020b/EMX_work/tcoil_tcoil2789.work" "tcoil2789.gds")

cv_schematic = dbOpenCellViewByType("tcoil" "tcoil_master" "schematic")
CCSchangeParam( "tcoil" "tcoil_master" "schematic" "tcoil3_mmw" "pneo" "60" )
CCSchangeParam( "tcoil" "tcoil_master" "schematic" "tcoil3_mmw" "ctapLocation" "bot" )
CCSchangeParam( "tcoil" "tcoil_master" "schematic" "tcoil3_mmw" "od" "64u" )
CCSchangeParam( "tcoil" "tcoil_master" "schematic" "tcoil3_mmw" "w" "4.2u" )
CCSchangeParam( "tcoil" "tcoil_master" "schematic" "tcoil3_mmw" "neo" "4" )
CCSchangeParam( "tcoil" "tcoil_master" "schematic" "tcoil3_mmw" "nei" "5" )
lxGenFromSource( cv_schematic )
cv_layout = dbOpenCellViewByType("tcoil" "tcoil_master" "layout")
MovePinsToInstances( cv_schematic cv_layout )
StreamOutGDS("tcoil" "tcoil_master" "layout" "/autofs/fs1.ece/fs1.eecg.tcc/lizongh2/gf22x-1020b/EMX_work/tcoil_tcoil2790.work" "tcoil2790.gds")

cv_schematic = dbOpenCellViewByType("tcoil" "tcoil_master" "schematic")
CCSchangeParam( "tcoil" "tcoil_master" "schematic" "tcoil3_mmw" "pneo" "60" )
CCSchangeParam( "tcoil" "tcoil_master" "schematic" "tcoil3_mmw" "ctapLocation" "bot" )
CCSchangeParam( "tcoil" "tcoil_master" "schematic" "tcoil3_mmw" "od" "64u" )
CCSchangeParam( "tcoil" "tcoil_master" "schematic" "tcoil3_mmw" "w" "4.2u" )
CCSchangeParam( "tcoil" "tcoil_master" "schematic" "tcoil3_mmw" "neo" "6" )
CCSchangeParam( "tcoil" "tcoil_master" "schematic" "tcoil3_mmw" "nei" "5" )
lxGenFromSource( cv_schematic )
cv_layout = dbOpenCellViewByType("tcoil" "tcoil_master" "layout")
MovePinsToInstances( cv_schematic cv_layout )
StreamOutGDS("tcoil" "tcoil_master" "layout" "/autofs/fs1.ece/fs1.eecg.tcc/lizongh2/gf22x-1020b/EMX_work/tcoil_tcoil2791.work" "tcoil2791.gds")

cv_schematic = dbOpenCellViewByType("tcoil" "tcoil_master" "schematic")
CCSchangeParam( "tcoil" "tcoil_master" "schematic" "tcoil3_mmw" "pneo" "60" )
CCSchangeParam( "tcoil" "tcoil_master" "schematic" "tcoil3_mmw" "ctapLocation" "bot" )
CCSchangeParam( "tcoil" "tcoil_master" "schematic" "tcoil3_mmw" "od" "64u" )
CCSchangeParam( "tcoil" "tcoil_master" "schematic" "tcoil3_mmw" "w" "4.2u" )
CCSchangeParam( "tcoil" "tcoil_master" "schematic" "tcoil3_mmw" "neo" "8" )
CCSchangeParam( "tcoil" "tcoil_master" "schematic" "tcoil3_mmw" "nei" "5" )
lxGenFromSource( cv_schematic )
cv_layout = dbOpenCellViewByType("tcoil" "tcoil_master" "layout")
MovePinsToInstances( cv_schematic cv_layout )
StreamOutGDS("tcoil" "tcoil_master" "layout" "/autofs/fs1.ece/fs1.eecg.tcc/lizongh2/gf22x-1020b/EMX_work/tcoil_tcoil2792.work" "tcoil2792.gds")

cv_schematic = dbOpenCellViewByType("tcoil" "tcoil_master" "schematic")
CCSchangeParam( "tcoil" "tcoil_master" "schematic" "tcoil3_mmw" "pneo" "60" )
CCSchangeParam( "tcoil" "tcoil_master" "schematic" "tcoil3_mmw" "ctapLocation" "bot" )
CCSchangeParam( "tcoil" "tcoil_master" "schematic" "tcoil3_mmw" "od" "64u" )
CCSchangeParam( "tcoil" "tcoil_master" "schematic" "tcoil3_mmw" "w" "4.2u" )
CCSchangeParam( "tcoil" "tcoil_master" "schematic" "tcoil3_mmw" "neo" "10" )
CCSchangeParam( "tcoil" "tcoil_master" "schematic" "tcoil3_mmw" "nei" "5" )
lxGenFromSource( cv_schematic )
cv_layout = dbOpenCellViewByType("tcoil" "tcoil_master" "layout")
MovePinsToInstances( cv_schematic cv_layout )
StreamOutGDS("tcoil" "tcoil_master" "layout" "/autofs/fs1.ece/fs1.eecg.tcc/lizongh2/gf22x-1020b/EMX_work/tcoil_tcoil2793.work" "tcoil2793.gds")

cv_schematic = dbOpenCellViewByType("tcoil" "tcoil_master" "schematic")
CCSchangeParam( "tcoil" "tcoil_master" "schematic" "tcoil3_mmw" "pneo" "60" )
CCSchangeParam( "tcoil" "tcoil_master" "schematic" "tcoil3_mmw" "ctapLocation" "bot" )
CCSchangeParam( "tcoil" "tcoil_master" "schematic" "tcoil3_mmw" "od" "64u" )
CCSchangeParam( "tcoil" "tcoil_master" "schematic" "tcoil3_mmw" "w" "4.2u" )
CCSchangeParam( "tcoil" "tcoil_master" "schematic" "tcoil3_mmw" "neo" "12" )
CCSchangeParam( "tcoil" "tcoil_master" "schematic" "tcoil3_mmw" "nei" "5" )
lxGenFromSource( cv_schematic )
cv_layout = dbOpenCellViewByType("tcoil" "tcoil_master" "layout")
MovePinsToInstances( cv_schematic cv_layout )
StreamOutGDS("tcoil" "tcoil_master" "layout" "/autofs/fs1.ece/fs1.eecg.tcc/lizongh2/gf22x-1020b/EMX_work/tcoil_tcoil2794.work" "tcoil2794.gds")

cv_schematic = dbOpenCellViewByType("tcoil" "tcoil_master" "schematic")
CCSchangeParam( "tcoil" "tcoil_master" "schematic" "tcoil3_mmw" "pneo" "60" )
CCSchangeParam( "tcoil" "tcoil_master" "schematic" "tcoil3_mmw" "ctapLocation" "bot" )
CCSchangeParam( "tcoil" "tcoil_master" "schematic" "tcoil3_mmw" "od" "64u" )
CCSchangeParam( "tcoil" "tcoil_master" "schematic" "tcoil3_mmw" "w" "5.0u" )
CCSchangeParam( "tcoil" "tcoil_master" "schematic" "tcoil3_mmw" "neo" "4" )
CCSchangeParam( "tcoil" "tcoil_master" "schematic" "tcoil3_mmw" "nei" "5" )
lxGenFromSource( cv_schematic )
cv_layout = dbOpenCellViewByType("tcoil" "tcoil_master" "layout")
MovePinsToInstances( cv_schematic cv_layout )
StreamOutGDS("tcoil" "tcoil_master" "layout" "/autofs/fs1.ece/fs1.eecg.tcc/lizongh2/gf22x-1020b/EMX_work/tcoil_tcoil2795.work" "tcoil2795.gds")

cv_schematic = dbOpenCellViewByType("tcoil" "tcoil_master" "schematic")
CCSchangeParam( "tcoil" "tcoil_master" "schematic" "tcoil3_mmw" "pneo" "60" )
CCSchangeParam( "tcoil" "tcoil_master" "schematic" "tcoil3_mmw" "ctapLocation" "bot" )
CCSchangeParam( "tcoil" "tcoil_master" "schematic" "tcoil3_mmw" "od" "64u" )
CCSchangeParam( "tcoil" "tcoil_master" "schematic" "tcoil3_mmw" "w" "5.0u" )
CCSchangeParam( "tcoil" "tcoil_master" "schematic" "tcoil3_mmw" "neo" "6" )
CCSchangeParam( "tcoil" "tcoil_master" "schematic" "tcoil3_mmw" "nei" "5" )
lxGenFromSource( cv_schematic )
cv_layout = dbOpenCellViewByType("tcoil" "tcoil_master" "layout")
MovePinsToInstances( cv_schematic cv_layout )
StreamOutGDS("tcoil" "tcoil_master" "layout" "/autofs/fs1.ece/fs1.eecg.tcc/lizongh2/gf22x-1020b/EMX_work/tcoil_tcoil2796.work" "tcoil2796.gds")

cv_schematic = dbOpenCellViewByType("tcoil" "tcoil_master" "schematic")
CCSchangeParam( "tcoil" "tcoil_master" "schematic" "tcoil3_mmw" "pneo" "60" )
CCSchangeParam( "tcoil" "tcoil_master" "schematic" "tcoil3_mmw" "ctapLocation" "bot" )
CCSchangeParam( "tcoil" "tcoil_master" "schematic" "tcoil3_mmw" "od" "64u" )
CCSchangeParam( "tcoil" "tcoil_master" "schematic" "tcoil3_mmw" "w" "5.0u" )
CCSchangeParam( "tcoil" "tcoil_master" "schematic" "tcoil3_mmw" "neo" "8" )
CCSchangeParam( "tcoil" "tcoil_master" "schematic" "tcoil3_mmw" "nei" "5" )
lxGenFromSource( cv_schematic )
cv_layout = dbOpenCellViewByType("tcoil" "tcoil_master" "layout")
MovePinsToInstances( cv_schematic cv_layout )
StreamOutGDS("tcoil" "tcoil_master" "layout" "/autofs/fs1.ece/fs1.eecg.tcc/lizongh2/gf22x-1020b/EMX_work/tcoil_tcoil2797.work" "tcoil2797.gds")

cv_schematic = dbOpenCellViewByType("tcoil" "tcoil_master" "schematic")
CCSchangeParam( "tcoil" "tcoil_master" "schematic" "tcoil3_mmw" "pneo" "60" )
CCSchangeParam( "tcoil" "tcoil_master" "schematic" "tcoil3_mmw" "ctapLocation" "bot" )
CCSchangeParam( "tcoil" "tcoil_master" "schematic" "tcoil3_mmw" "od" "64u" )
CCSchangeParam( "tcoil" "tcoil_master" "schematic" "tcoil3_mmw" "w" "5.0u" )
CCSchangeParam( "tcoil" "tcoil_master" "schematic" "tcoil3_mmw" "neo" "10" )
CCSchangeParam( "tcoil" "tcoil_master" "schematic" "tcoil3_mmw" "nei" "5" )
lxGenFromSource( cv_schematic )
cv_layout = dbOpenCellViewByType("tcoil" "tcoil_master" "layout")
MovePinsToInstances( cv_schematic cv_layout )
StreamOutGDS("tcoil" "tcoil_master" "layout" "/autofs/fs1.ece/fs1.eecg.tcc/lizongh2/gf22x-1020b/EMX_work/tcoil_tcoil2798.work" "tcoil2798.gds")

cv_schematic = dbOpenCellViewByType("tcoil" "tcoil_master" "schematic")
CCSchangeParam( "tcoil" "tcoil_master" "schematic" "tcoil3_mmw" "pneo" "60" )
CCSchangeParam( "tcoil" "tcoil_master" "schematic" "tcoil3_mmw" "ctapLocation" "bot" )
CCSchangeParam( "tcoil" "tcoil_master" "schematic" "tcoil3_mmw" "od" "64u" )
CCSchangeParam( "tcoil" "tcoil_master" "schematic" "tcoil3_mmw" "w" "5.0u" )
CCSchangeParam( "tcoil" "tcoil_master" "schematic" "tcoil3_mmw" "neo" "12" )
CCSchangeParam( "tcoil" "tcoil_master" "schematic" "tcoil3_mmw" "nei" "5" )
lxGenFromSource( cv_schematic )
cv_layout = dbOpenCellViewByType("tcoil" "tcoil_master" "layout")
MovePinsToInstances( cv_schematic cv_layout )
StreamOutGDS("tcoil" "tcoil_master" "layout" "/autofs/fs1.ece/fs1.eecg.tcc/lizongh2/gf22x-1020b/EMX_work/tcoil_tcoil2799.work" "tcoil2799.gds")

cv_schematic = dbOpenCellViewByType("tcoil" "tcoil_master" "schematic")
CCSchangeParam( "tcoil" "tcoil_master" "schematic" "tcoil3_mmw" "pneo" "60" )
CCSchangeParam( "tcoil" "tcoil_master" "schematic" "tcoil3_mmw" "ctapLocation" "bot" )
CCSchangeParam( "tcoil" "tcoil_master" "schematic" "tcoil3_mmw" "od" "66u" )
CCSchangeParam( "tcoil" "tcoil_master" "schematic" "tcoil3_mmw" "w" "2.4u" )
CCSchangeParam( "tcoil" "tcoil_master" "schematic" "tcoil3_mmw" "neo" "4" )
CCSchangeParam( "tcoil" "tcoil_master" "schematic" "tcoil3_mmw" "nei" "5" )
lxGenFromSource( cv_schematic )
cv_layout = dbOpenCellViewByType("tcoil" "tcoil_master" "layout")
MovePinsToInstances( cv_schematic cv_layout )
StreamOutGDS("tcoil" "tcoil_master" "layout" "/autofs/fs1.ece/fs1.eecg.tcc/lizongh2/gf22x-1020b/EMX_work/tcoil_tcoil2800.work" "tcoil2800.gds")

cv_schematic = dbOpenCellViewByType("tcoil" "tcoil_master" "schematic")
CCSchangeParam( "tcoil" "tcoil_master" "schematic" "tcoil3_mmw" "pneo" "60" )
CCSchangeParam( "tcoil" "tcoil_master" "schematic" "tcoil3_mmw" "ctapLocation" "bot" )
CCSchangeParam( "tcoil" "tcoil_master" "schematic" "tcoil3_mmw" "od" "66u" )
CCSchangeParam( "tcoil" "tcoil_master" "schematic" "tcoil3_mmw" "w" "2.4u" )
CCSchangeParam( "tcoil" "tcoil_master" "schematic" "tcoil3_mmw" "neo" "6" )
CCSchangeParam( "tcoil" "tcoil_master" "schematic" "tcoil3_mmw" "nei" "5" )
lxGenFromSource( cv_schematic )
cv_layout = dbOpenCellViewByType("tcoil" "tcoil_master" "layout")
MovePinsToInstances( cv_schematic cv_layout )
StreamOutGDS("tcoil" "tcoil_master" "layout" "/autofs/fs1.ece/fs1.eecg.tcc/lizongh2/gf22x-1020b/EMX_work/tcoil_tcoil2801.work" "tcoil2801.gds")

cv_schematic = dbOpenCellViewByType("tcoil" "tcoil_master" "schematic")
CCSchangeParam( "tcoil" "tcoil_master" "schematic" "tcoil3_mmw" "pneo" "60" )
CCSchangeParam( "tcoil" "tcoil_master" "schematic" "tcoil3_mmw" "ctapLocation" "bot" )
CCSchangeParam( "tcoil" "tcoil_master" "schematic" "tcoil3_mmw" "od" "66u" )
CCSchangeParam( "tcoil" "tcoil_master" "schematic" "tcoil3_mmw" "w" "2.4u" )
CCSchangeParam( "tcoil" "tcoil_master" "schematic" "tcoil3_mmw" "neo" "8" )
CCSchangeParam( "tcoil" "tcoil_master" "schematic" "tcoil3_mmw" "nei" "5" )
lxGenFromSource( cv_schematic )
cv_layout = dbOpenCellViewByType("tcoil" "tcoil_master" "layout")
MovePinsToInstances( cv_schematic cv_layout )
StreamOutGDS("tcoil" "tcoil_master" "layout" "/autofs/fs1.ece/fs1.eecg.tcc/lizongh2/gf22x-1020b/EMX_work/tcoil_tcoil2802.work" "tcoil2802.gds")

cv_schematic = dbOpenCellViewByType("tcoil" "tcoil_master" "schematic")
CCSchangeParam( "tcoil" "tcoil_master" "schematic" "tcoil3_mmw" "pneo" "60" )
CCSchangeParam( "tcoil" "tcoil_master" "schematic" "tcoil3_mmw" "ctapLocation" "bot" )
CCSchangeParam( "tcoil" "tcoil_master" "schematic" "tcoil3_mmw" "od" "66u" )
CCSchangeParam( "tcoil" "tcoil_master" "schematic" "tcoil3_mmw" "w" "2.4u" )
CCSchangeParam( "tcoil" "tcoil_master" "schematic" "tcoil3_mmw" "neo" "10" )
CCSchangeParam( "tcoil" "tcoil_master" "schematic" "tcoil3_mmw" "nei" "5" )
lxGenFromSource( cv_schematic )
cv_layout = dbOpenCellViewByType("tcoil" "tcoil_master" "layout")
MovePinsToInstances( cv_schematic cv_layout )
StreamOutGDS("tcoil" "tcoil_master" "layout" "/autofs/fs1.ece/fs1.eecg.tcc/lizongh2/gf22x-1020b/EMX_work/tcoil_tcoil2803.work" "tcoil2803.gds")

cv_schematic = dbOpenCellViewByType("tcoil" "tcoil_master" "schematic")
CCSchangeParam( "tcoil" "tcoil_master" "schematic" "tcoil3_mmw" "pneo" "60" )
CCSchangeParam( "tcoil" "tcoil_master" "schematic" "tcoil3_mmw" "ctapLocation" "bot" )
CCSchangeParam( "tcoil" "tcoil_master" "schematic" "tcoil3_mmw" "od" "66u" )
CCSchangeParam( "tcoil" "tcoil_master" "schematic" "tcoil3_mmw" "w" "2.4u" )
CCSchangeParam( "tcoil" "tcoil_master" "schematic" "tcoil3_mmw" "neo" "12" )
CCSchangeParam( "tcoil" "tcoil_master" "schematic" "tcoil3_mmw" "nei" "5" )
lxGenFromSource( cv_schematic )
cv_layout = dbOpenCellViewByType("tcoil" "tcoil_master" "layout")
MovePinsToInstances( cv_schematic cv_layout )
StreamOutGDS("tcoil" "tcoil_master" "layout" "/autofs/fs1.ece/fs1.eecg.tcc/lizongh2/gf22x-1020b/EMX_work/tcoil_tcoil2804.work" "tcoil2804.gds")

cv_schematic = dbOpenCellViewByType("tcoil" "tcoil_master" "schematic")
CCSchangeParam( "tcoil" "tcoil_master" "schematic" "tcoil3_mmw" "pneo" "60" )
CCSchangeParam( "tcoil" "tcoil_master" "schematic" "tcoil3_mmw" "ctapLocation" "bot" )
CCSchangeParam( "tcoil" "tcoil_master" "schematic" "tcoil3_mmw" "od" "66u" )
CCSchangeParam( "tcoil" "tcoil_master" "schematic" "tcoil3_mmw" "w" "4.2u" )
CCSchangeParam( "tcoil" "tcoil_master" "schematic" "tcoil3_mmw" "neo" "4" )
CCSchangeParam( "tcoil" "tcoil_master" "schematic" "tcoil3_mmw" "nei" "5" )
lxGenFromSource( cv_schematic )
cv_layout = dbOpenCellViewByType("tcoil" "tcoil_master" "layout")
MovePinsToInstances( cv_schematic cv_layout )
StreamOutGDS("tcoil" "tcoil_master" "layout" "/autofs/fs1.ece/fs1.eecg.tcc/lizongh2/gf22x-1020b/EMX_work/tcoil_tcoil2805.work" "tcoil2805.gds")

cv_schematic = dbOpenCellViewByType("tcoil" "tcoil_master" "schematic")
CCSchangeParam( "tcoil" "tcoil_master" "schematic" "tcoil3_mmw" "pneo" "60" )
CCSchangeParam( "tcoil" "tcoil_master" "schematic" "tcoil3_mmw" "ctapLocation" "bot" )
CCSchangeParam( "tcoil" "tcoil_master" "schematic" "tcoil3_mmw" "od" "66u" )
CCSchangeParam( "tcoil" "tcoil_master" "schematic" "tcoil3_mmw" "w" "4.2u" )
CCSchangeParam( "tcoil" "tcoil_master" "schematic" "tcoil3_mmw" "neo" "6" )
CCSchangeParam( "tcoil" "tcoil_master" "schematic" "tcoil3_mmw" "nei" "5" )
lxGenFromSource( cv_schematic )
cv_layout = dbOpenCellViewByType("tcoil" "tcoil_master" "layout")
MovePinsToInstances( cv_schematic cv_layout )
StreamOutGDS("tcoil" "tcoil_master" "layout" "/autofs/fs1.ece/fs1.eecg.tcc/lizongh2/gf22x-1020b/EMX_work/tcoil_tcoil2806.work" "tcoil2806.gds")

cv_schematic = dbOpenCellViewByType("tcoil" "tcoil_master" "schematic")
CCSchangeParam( "tcoil" "tcoil_master" "schematic" "tcoil3_mmw" "pneo" "60" )
CCSchangeParam( "tcoil" "tcoil_master" "schematic" "tcoil3_mmw" "ctapLocation" "bot" )
CCSchangeParam( "tcoil" "tcoil_master" "schematic" "tcoil3_mmw" "od" "66u" )
CCSchangeParam( "tcoil" "tcoil_master" "schematic" "tcoil3_mmw" "w" "4.2u" )
CCSchangeParam( "tcoil" "tcoil_master" "schematic" "tcoil3_mmw" "neo" "8" )
CCSchangeParam( "tcoil" "tcoil_master" "schematic" "tcoil3_mmw" "nei" "5" )
lxGenFromSource( cv_schematic )
cv_layout = dbOpenCellViewByType("tcoil" "tcoil_master" "layout")
MovePinsToInstances( cv_schematic cv_layout )
StreamOutGDS("tcoil" "tcoil_master" "layout" "/autofs/fs1.ece/fs1.eecg.tcc/lizongh2/gf22x-1020b/EMX_work/tcoil_tcoil2807.work" "tcoil2807.gds")

cv_schematic = dbOpenCellViewByType("tcoil" "tcoil_master" "schematic")
CCSchangeParam( "tcoil" "tcoil_master" "schematic" "tcoil3_mmw" "pneo" "60" )
CCSchangeParam( "tcoil" "tcoil_master" "schematic" "tcoil3_mmw" "ctapLocation" "bot" )
CCSchangeParam( "tcoil" "tcoil_master" "schematic" "tcoil3_mmw" "od" "66u" )
CCSchangeParam( "tcoil" "tcoil_master" "schematic" "tcoil3_mmw" "w" "4.2u" )
CCSchangeParam( "tcoil" "tcoil_master" "schematic" "tcoil3_mmw" "neo" "10" )
CCSchangeParam( "tcoil" "tcoil_master" "schematic" "tcoil3_mmw" "nei" "5" )
lxGenFromSource( cv_schematic )
cv_layout = dbOpenCellViewByType("tcoil" "tcoil_master" "layout")
MovePinsToInstances( cv_schematic cv_layout )
StreamOutGDS("tcoil" "tcoil_master" "layout" "/autofs/fs1.ece/fs1.eecg.tcc/lizongh2/gf22x-1020b/EMX_work/tcoil_tcoil2808.work" "tcoil2808.gds")

cv_schematic = dbOpenCellViewByType("tcoil" "tcoil_master" "schematic")
CCSchangeParam( "tcoil" "tcoil_master" "schematic" "tcoil3_mmw" "pneo" "60" )
CCSchangeParam( "tcoil" "tcoil_master" "schematic" "tcoil3_mmw" "ctapLocation" "bot" )
CCSchangeParam( "tcoil" "tcoil_master" "schematic" "tcoil3_mmw" "od" "66u" )
CCSchangeParam( "tcoil" "tcoil_master" "schematic" "tcoil3_mmw" "w" "4.2u" )
CCSchangeParam( "tcoil" "tcoil_master" "schematic" "tcoil3_mmw" "neo" "12" )
CCSchangeParam( "tcoil" "tcoil_master" "schematic" "tcoil3_mmw" "nei" "5" )
lxGenFromSource( cv_schematic )
cv_layout = dbOpenCellViewByType("tcoil" "tcoil_master" "layout")
MovePinsToInstances( cv_schematic cv_layout )
StreamOutGDS("tcoil" "tcoil_master" "layout" "/autofs/fs1.ece/fs1.eecg.tcc/lizongh2/gf22x-1020b/EMX_work/tcoil_tcoil2809.work" "tcoil2809.gds")

cv_schematic = dbOpenCellViewByType("tcoil" "tcoil_master" "schematic")
CCSchangeParam( "tcoil" "tcoil_master" "schematic" "tcoil3_mmw" "pneo" "60" )
CCSchangeParam( "tcoil" "tcoil_master" "schematic" "tcoil3_mmw" "ctapLocation" "bot" )
CCSchangeParam( "tcoil" "tcoil_master" "schematic" "tcoil3_mmw" "od" "66u" )
CCSchangeParam( "tcoil" "tcoil_master" "schematic" "tcoil3_mmw" "w" "5.0u" )
CCSchangeParam( "tcoil" "tcoil_master" "schematic" "tcoil3_mmw" "neo" "4" )
CCSchangeParam( "tcoil" "tcoil_master" "schematic" "tcoil3_mmw" "nei" "5" )
lxGenFromSource( cv_schematic )
cv_layout = dbOpenCellViewByType("tcoil" "tcoil_master" "layout")
MovePinsToInstances( cv_schematic cv_layout )
StreamOutGDS("tcoil" "tcoil_master" "layout" "/autofs/fs1.ece/fs1.eecg.tcc/lizongh2/gf22x-1020b/EMX_work/tcoil_tcoil2810.work" "tcoil2810.gds")

cv_schematic = dbOpenCellViewByType("tcoil" "tcoil_master" "schematic")
CCSchangeParam( "tcoil" "tcoil_master" "schematic" "tcoil3_mmw" "pneo" "60" )
CCSchangeParam( "tcoil" "tcoil_master" "schematic" "tcoil3_mmw" "ctapLocation" "bot" )
CCSchangeParam( "tcoil" "tcoil_master" "schematic" "tcoil3_mmw" "od" "66u" )
CCSchangeParam( "tcoil" "tcoil_master" "schematic" "tcoil3_mmw" "w" "5.0u" )
CCSchangeParam( "tcoil" "tcoil_master" "schematic" "tcoil3_mmw" "neo" "6" )
CCSchangeParam( "tcoil" "tcoil_master" "schematic" "tcoil3_mmw" "nei" "5" )
lxGenFromSource( cv_schematic )
cv_layout = dbOpenCellViewByType("tcoil" "tcoil_master" "layout")
MovePinsToInstances( cv_schematic cv_layout )
StreamOutGDS("tcoil" "tcoil_master" "layout" "/autofs/fs1.ece/fs1.eecg.tcc/lizongh2/gf22x-1020b/EMX_work/tcoil_tcoil2811.work" "tcoil2811.gds")

cv_schematic = dbOpenCellViewByType("tcoil" "tcoil_master" "schematic")
CCSchangeParam( "tcoil" "tcoil_master" "schematic" "tcoil3_mmw" "pneo" "60" )
CCSchangeParam( "tcoil" "tcoil_master" "schematic" "tcoil3_mmw" "ctapLocation" "bot" )
CCSchangeParam( "tcoil" "tcoil_master" "schematic" "tcoil3_mmw" "od" "66u" )
CCSchangeParam( "tcoil" "tcoil_master" "schematic" "tcoil3_mmw" "w" "5.0u" )
CCSchangeParam( "tcoil" "tcoil_master" "schematic" "tcoil3_mmw" "neo" "8" )
CCSchangeParam( "tcoil" "tcoil_master" "schematic" "tcoil3_mmw" "nei" "5" )
lxGenFromSource( cv_schematic )
cv_layout = dbOpenCellViewByType("tcoil" "tcoil_master" "layout")
MovePinsToInstances( cv_schematic cv_layout )
StreamOutGDS("tcoil" "tcoil_master" "layout" "/autofs/fs1.ece/fs1.eecg.tcc/lizongh2/gf22x-1020b/EMX_work/tcoil_tcoil2812.work" "tcoil2812.gds")

cv_schematic = dbOpenCellViewByType("tcoil" "tcoil_master" "schematic")
CCSchangeParam( "tcoil" "tcoil_master" "schematic" "tcoil3_mmw" "pneo" "60" )
CCSchangeParam( "tcoil" "tcoil_master" "schematic" "tcoil3_mmw" "ctapLocation" "bot" )
CCSchangeParam( "tcoil" "tcoil_master" "schematic" "tcoil3_mmw" "od" "66u" )
CCSchangeParam( "tcoil" "tcoil_master" "schematic" "tcoil3_mmw" "w" "5.0u" )
CCSchangeParam( "tcoil" "tcoil_master" "schematic" "tcoil3_mmw" "neo" "10" )
CCSchangeParam( "tcoil" "tcoil_master" "schematic" "tcoil3_mmw" "nei" "5" )
lxGenFromSource( cv_schematic )
cv_layout = dbOpenCellViewByType("tcoil" "tcoil_master" "layout")
MovePinsToInstances( cv_schematic cv_layout )
StreamOutGDS("tcoil" "tcoil_master" "layout" "/autofs/fs1.ece/fs1.eecg.tcc/lizongh2/gf22x-1020b/EMX_work/tcoil_tcoil2813.work" "tcoil2813.gds")

cv_schematic = dbOpenCellViewByType("tcoil" "tcoil_master" "schematic")
CCSchangeParam( "tcoil" "tcoil_master" "schematic" "tcoil3_mmw" "pneo" "60" )
CCSchangeParam( "tcoil" "tcoil_master" "schematic" "tcoil3_mmw" "ctapLocation" "bot" )
CCSchangeParam( "tcoil" "tcoil_master" "schematic" "tcoil3_mmw" "od" "66u" )
CCSchangeParam( "tcoil" "tcoil_master" "schematic" "tcoil3_mmw" "w" "5.0u" )
CCSchangeParam( "tcoil" "tcoil_master" "schematic" "tcoil3_mmw" "neo" "12" )
CCSchangeParam( "tcoil" "tcoil_master" "schematic" "tcoil3_mmw" "nei" "5" )
lxGenFromSource( cv_schematic )
cv_layout = dbOpenCellViewByType("tcoil" "tcoil_master" "layout")
MovePinsToInstances( cv_schematic cv_layout )
StreamOutGDS("tcoil" "tcoil_master" "layout" "/autofs/fs1.ece/fs1.eecg.tcc/lizongh2/gf22x-1020b/EMX_work/tcoil_tcoil2814.work" "tcoil2814.gds")

cv_schematic = dbOpenCellViewByType("tcoil" "tcoil_master" "schematic")
CCSchangeParam( "tcoil" "tcoil_master" "schematic" "tcoil3_mmw" "pneo" "60" )
CCSchangeParam( "tcoil" "tcoil_master" "schematic" "tcoil3_mmw" "ctapLocation" "bot" )
CCSchangeParam( "tcoil" "tcoil_master" "schematic" "tcoil3_mmw" "od" "68u" )
CCSchangeParam( "tcoil" "tcoil_master" "schematic" "tcoil3_mmw" "w" "2.4u" )
CCSchangeParam( "tcoil" "tcoil_master" "schematic" "tcoil3_mmw" "neo" "4" )
CCSchangeParam( "tcoil" "tcoil_master" "schematic" "tcoil3_mmw" "nei" "5" )
lxGenFromSource( cv_schematic )
cv_layout = dbOpenCellViewByType("tcoil" "tcoil_master" "layout")
MovePinsToInstances( cv_schematic cv_layout )
StreamOutGDS("tcoil" "tcoil_master" "layout" "/autofs/fs1.ece/fs1.eecg.tcc/lizongh2/gf22x-1020b/EMX_work/tcoil_tcoil2815.work" "tcoil2815.gds")

cv_schematic = dbOpenCellViewByType("tcoil" "tcoil_master" "schematic")
CCSchangeParam( "tcoil" "tcoil_master" "schematic" "tcoil3_mmw" "pneo" "60" )
CCSchangeParam( "tcoil" "tcoil_master" "schematic" "tcoil3_mmw" "ctapLocation" "bot" )
CCSchangeParam( "tcoil" "tcoil_master" "schematic" "tcoil3_mmw" "od" "68u" )
CCSchangeParam( "tcoil" "tcoil_master" "schematic" "tcoil3_mmw" "w" "2.4u" )
CCSchangeParam( "tcoil" "tcoil_master" "schematic" "tcoil3_mmw" "neo" "6" )
CCSchangeParam( "tcoil" "tcoil_master" "schematic" "tcoil3_mmw" "nei" "5" )
lxGenFromSource( cv_schematic )
cv_layout = dbOpenCellViewByType("tcoil" "tcoil_master" "layout")
MovePinsToInstances( cv_schematic cv_layout )
StreamOutGDS("tcoil" "tcoil_master" "layout" "/autofs/fs1.ece/fs1.eecg.tcc/lizongh2/gf22x-1020b/EMX_work/tcoil_tcoil2816.work" "tcoil2816.gds")

cv_schematic = dbOpenCellViewByType("tcoil" "tcoil_master" "schematic")
CCSchangeParam( "tcoil" "tcoil_master" "schematic" "tcoil3_mmw" "pneo" "60" )
CCSchangeParam( "tcoil" "tcoil_master" "schematic" "tcoil3_mmw" "ctapLocation" "bot" )
CCSchangeParam( "tcoil" "tcoil_master" "schematic" "tcoil3_mmw" "od" "68u" )
CCSchangeParam( "tcoil" "tcoil_master" "schematic" "tcoil3_mmw" "w" "2.4u" )
CCSchangeParam( "tcoil" "tcoil_master" "schematic" "tcoil3_mmw" "neo" "8" )
CCSchangeParam( "tcoil" "tcoil_master" "schematic" "tcoil3_mmw" "nei" "5" )
lxGenFromSource( cv_schematic )
cv_layout = dbOpenCellViewByType("tcoil" "tcoil_master" "layout")
MovePinsToInstances( cv_schematic cv_layout )
StreamOutGDS("tcoil" "tcoil_master" "layout" "/autofs/fs1.ece/fs1.eecg.tcc/lizongh2/gf22x-1020b/EMX_work/tcoil_tcoil2817.work" "tcoil2817.gds")

cv_schematic = dbOpenCellViewByType("tcoil" "tcoil_master" "schematic")
CCSchangeParam( "tcoil" "tcoil_master" "schematic" "tcoil3_mmw" "pneo" "60" )
CCSchangeParam( "tcoil" "tcoil_master" "schematic" "tcoil3_mmw" "ctapLocation" "bot" )
CCSchangeParam( "tcoil" "tcoil_master" "schematic" "tcoil3_mmw" "od" "68u" )
CCSchangeParam( "tcoil" "tcoil_master" "schematic" "tcoil3_mmw" "w" "2.4u" )
CCSchangeParam( "tcoil" "tcoil_master" "schematic" "tcoil3_mmw" "neo" "10" )
CCSchangeParam( "tcoil" "tcoil_master" "schematic" "tcoil3_mmw" "nei" "5" )
lxGenFromSource( cv_schematic )
cv_layout = dbOpenCellViewByType("tcoil" "tcoil_master" "layout")
MovePinsToInstances( cv_schematic cv_layout )
StreamOutGDS("tcoil" "tcoil_master" "layout" "/autofs/fs1.ece/fs1.eecg.tcc/lizongh2/gf22x-1020b/EMX_work/tcoil_tcoil2818.work" "tcoil2818.gds")

cv_schematic = dbOpenCellViewByType("tcoil" "tcoil_master" "schematic")
CCSchangeParam( "tcoil" "tcoil_master" "schematic" "tcoil3_mmw" "pneo" "60" )
CCSchangeParam( "tcoil" "tcoil_master" "schematic" "tcoil3_mmw" "ctapLocation" "bot" )
CCSchangeParam( "tcoil" "tcoil_master" "schematic" "tcoil3_mmw" "od" "68u" )
CCSchangeParam( "tcoil" "tcoil_master" "schematic" "tcoil3_mmw" "w" "2.4u" )
CCSchangeParam( "tcoil" "tcoil_master" "schematic" "tcoil3_mmw" "neo" "12" )
CCSchangeParam( "tcoil" "tcoil_master" "schematic" "tcoil3_mmw" "nei" "5" )
lxGenFromSource( cv_schematic )
cv_layout = dbOpenCellViewByType("tcoil" "tcoil_master" "layout")
MovePinsToInstances( cv_schematic cv_layout )
StreamOutGDS("tcoil" "tcoil_master" "layout" "/autofs/fs1.ece/fs1.eecg.tcc/lizongh2/gf22x-1020b/EMX_work/tcoil_tcoil2819.work" "tcoil2819.gds")

cv_schematic = dbOpenCellViewByType("tcoil" "tcoil_master" "schematic")
CCSchangeParam( "tcoil" "tcoil_master" "schematic" "tcoil3_mmw" "pneo" "60" )
CCSchangeParam( "tcoil" "tcoil_master" "schematic" "tcoil3_mmw" "ctapLocation" "bot" )
CCSchangeParam( "tcoil" "tcoil_master" "schematic" "tcoil3_mmw" "od" "68u" )
CCSchangeParam( "tcoil" "tcoil_master" "schematic" "tcoil3_mmw" "w" "4.2u" )
CCSchangeParam( "tcoil" "tcoil_master" "schematic" "tcoil3_mmw" "neo" "4" )
CCSchangeParam( "tcoil" "tcoil_master" "schematic" "tcoil3_mmw" "nei" "5" )
lxGenFromSource( cv_schematic )
cv_layout = dbOpenCellViewByType("tcoil" "tcoil_master" "layout")
MovePinsToInstances( cv_schematic cv_layout )
StreamOutGDS("tcoil" "tcoil_master" "layout" "/autofs/fs1.ece/fs1.eecg.tcc/lizongh2/gf22x-1020b/EMX_work/tcoil_tcoil2820.work" "tcoil2820.gds")

cv_schematic = dbOpenCellViewByType("tcoil" "tcoil_master" "schematic")
CCSchangeParam( "tcoil" "tcoil_master" "schematic" "tcoil3_mmw" "pneo" "60" )
CCSchangeParam( "tcoil" "tcoil_master" "schematic" "tcoil3_mmw" "ctapLocation" "bot" )
CCSchangeParam( "tcoil" "tcoil_master" "schematic" "tcoil3_mmw" "od" "68u" )
CCSchangeParam( "tcoil" "tcoil_master" "schematic" "tcoil3_mmw" "w" "4.2u" )
CCSchangeParam( "tcoil" "tcoil_master" "schematic" "tcoil3_mmw" "neo" "6" )
CCSchangeParam( "tcoil" "tcoil_master" "schematic" "tcoil3_mmw" "nei" "5" )
lxGenFromSource( cv_schematic )
cv_layout = dbOpenCellViewByType("tcoil" "tcoil_master" "layout")
MovePinsToInstances( cv_schematic cv_layout )
StreamOutGDS("tcoil" "tcoil_master" "layout" "/autofs/fs1.ece/fs1.eecg.tcc/lizongh2/gf22x-1020b/EMX_work/tcoil_tcoil2821.work" "tcoil2821.gds")

cv_schematic = dbOpenCellViewByType("tcoil" "tcoil_master" "schematic")
CCSchangeParam( "tcoil" "tcoil_master" "schematic" "tcoil3_mmw" "pneo" "60" )
CCSchangeParam( "tcoil" "tcoil_master" "schematic" "tcoil3_mmw" "ctapLocation" "bot" )
CCSchangeParam( "tcoil" "tcoil_master" "schematic" "tcoil3_mmw" "od" "68u" )
CCSchangeParam( "tcoil" "tcoil_master" "schematic" "tcoil3_mmw" "w" "4.2u" )
CCSchangeParam( "tcoil" "tcoil_master" "schematic" "tcoil3_mmw" "neo" "8" )
CCSchangeParam( "tcoil" "tcoil_master" "schematic" "tcoil3_mmw" "nei" "5" )
lxGenFromSource( cv_schematic )
cv_layout = dbOpenCellViewByType("tcoil" "tcoil_master" "layout")
MovePinsToInstances( cv_schematic cv_layout )
StreamOutGDS("tcoil" "tcoil_master" "layout" "/autofs/fs1.ece/fs1.eecg.tcc/lizongh2/gf22x-1020b/EMX_work/tcoil_tcoil2822.work" "tcoil2822.gds")

cv_schematic = dbOpenCellViewByType("tcoil" "tcoil_master" "schematic")
CCSchangeParam( "tcoil" "tcoil_master" "schematic" "tcoil3_mmw" "pneo" "60" )
CCSchangeParam( "tcoil" "tcoil_master" "schematic" "tcoil3_mmw" "ctapLocation" "bot" )
CCSchangeParam( "tcoil" "tcoil_master" "schematic" "tcoil3_mmw" "od" "68u" )
CCSchangeParam( "tcoil" "tcoil_master" "schematic" "tcoil3_mmw" "w" "4.2u" )
CCSchangeParam( "tcoil" "tcoil_master" "schematic" "tcoil3_mmw" "neo" "10" )
CCSchangeParam( "tcoil" "tcoil_master" "schematic" "tcoil3_mmw" "nei" "5" )
lxGenFromSource( cv_schematic )
cv_layout = dbOpenCellViewByType("tcoil" "tcoil_master" "layout")
MovePinsToInstances( cv_schematic cv_layout )
StreamOutGDS("tcoil" "tcoil_master" "layout" "/autofs/fs1.ece/fs1.eecg.tcc/lizongh2/gf22x-1020b/EMX_work/tcoil_tcoil2823.work" "tcoil2823.gds")

cv_schematic = dbOpenCellViewByType("tcoil" "tcoil_master" "schematic")
CCSchangeParam( "tcoil" "tcoil_master" "schematic" "tcoil3_mmw" "pneo" "60" )
CCSchangeParam( "tcoil" "tcoil_master" "schematic" "tcoil3_mmw" "ctapLocation" "bot" )
CCSchangeParam( "tcoil" "tcoil_master" "schematic" "tcoil3_mmw" "od" "68u" )
CCSchangeParam( "tcoil" "tcoil_master" "schematic" "tcoil3_mmw" "w" "4.2u" )
CCSchangeParam( "tcoil" "tcoil_master" "schematic" "tcoil3_mmw" "neo" "12" )
CCSchangeParam( "tcoil" "tcoil_master" "schematic" "tcoil3_mmw" "nei" "5" )
lxGenFromSource( cv_schematic )
cv_layout = dbOpenCellViewByType("tcoil" "tcoil_master" "layout")
MovePinsToInstances( cv_schematic cv_layout )
StreamOutGDS("tcoil" "tcoil_master" "layout" "/autofs/fs1.ece/fs1.eecg.tcc/lizongh2/gf22x-1020b/EMX_work/tcoil_tcoil2824.work" "tcoil2824.gds")

cv_schematic = dbOpenCellViewByType("tcoil" "tcoil_master" "schematic")
CCSchangeParam( "tcoil" "tcoil_master" "schematic" "tcoil3_mmw" "pneo" "60" )
CCSchangeParam( "tcoil" "tcoil_master" "schematic" "tcoil3_mmw" "ctapLocation" "bot" )
CCSchangeParam( "tcoil" "tcoil_master" "schematic" "tcoil3_mmw" "od" "68u" )
CCSchangeParam( "tcoil" "tcoil_master" "schematic" "tcoil3_mmw" "w" "5.0u" )
CCSchangeParam( "tcoil" "tcoil_master" "schematic" "tcoil3_mmw" "neo" "4" )
CCSchangeParam( "tcoil" "tcoil_master" "schematic" "tcoil3_mmw" "nei" "5" )
lxGenFromSource( cv_schematic )
cv_layout = dbOpenCellViewByType("tcoil" "tcoil_master" "layout")
MovePinsToInstances( cv_schematic cv_layout )
StreamOutGDS("tcoil" "tcoil_master" "layout" "/autofs/fs1.ece/fs1.eecg.tcc/lizongh2/gf22x-1020b/EMX_work/tcoil_tcoil2825.work" "tcoil2825.gds")

cv_schematic = dbOpenCellViewByType("tcoil" "tcoil_master" "schematic")
CCSchangeParam( "tcoil" "tcoil_master" "schematic" "tcoil3_mmw" "pneo" "60" )
CCSchangeParam( "tcoil" "tcoil_master" "schematic" "tcoil3_mmw" "ctapLocation" "bot" )
CCSchangeParam( "tcoil" "tcoil_master" "schematic" "tcoil3_mmw" "od" "68u" )
CCSchangeParam( "tcoil" "tcoil_master" "schematic" "tcoil3_mmw" "w" "5.0u" )
CCSchangeParam( "tcoil" "tcoil_master" "schematic" "tcoil3_mmw" "neo" "6" )
CCSchangeParam( "tcoil" "tcoil_master" "schematic" "tcoil3_mmw" "nei" "5" )
lxGenFromSource( cv_schematic )
cv_layout = dbOpenCellViewByType("tcoil" "tcoil_master" "layout")
MovePinsToInstances( cv_schematic cv_layout )
StreamOutGDS("tcoil" "tcoil_master" "layout" "/autofs/fs1.ece/fs1.eecg.tcc/lizongh2/gf22x-1020b/EMX_work/tcoil_tcoil2826.work" "tcoil2826.gds")

cv_schematic = dbOpenCellViewByType("tcoil" "tcoil_master" "schematic")
CCSchangeParam( "tcoil" "tcoil_master" "schematic" "tcoil3_mmw" "pneo" "60" )
CCSchangeParam( "tcoil" "tcoil_master" "schematic" "tcoil3_mmw" "ctapLocation" "bot" )
CCSchangeParam( "tcoil" "tcoil_master" "schematic" "tcoil3_mmw" "od" "68u" )
CCSchangeParam( "tcoil" "tcoil_master" "schematic" "tcoil3_mmw" "w" "5.0u" )
CCSchangeParam( "tcoil" "tcoil_master" "schematic" "tcoil3_mmw" "neo" "8" )
CCSchangeParam( "tcoil" "tcoil_master" "schematic" "tcoil3_mmw" "nei" "5" )
lxGenFromSource( cv_schematic )
cv_layout = dbOpenCellViewByType("tcoil" "tcoil_master" "layout")
MovePinsToInstances( cv_schematic cv_layout )
StreamOutGDS("tcoil" "tcoil_master" "layout" "/autofs/fs1.ece/fs1.eecg.tcc/lizongh2/gf22x-1020b/EMX_work/tcoil_tcoil2827.work" "tcoil2827.gds")

cv_schematic = dbOpenCellViewByType("tcoil" "tcoil_master" "schematic")
CCSchangeParam( "tcoil" "tcoil_master" "schematic" "tcoil3_mmw" "pneo" "60" )
CCSchangeParam( "tcoil" "tcoil_master" "schematic" "tcoil3_mmw" "ctapLocation" "bot" )
CCSchangeParam( "tcoil" "tcoil_master" "schematic" "tcoil3_mmw" "od" "68u" )
CCSchangeParam( "tcoil" "tcoil_master" "schematic" "tcoil3_mmw" "w" "5.0u" )
CCSchangeParam( "tcoil" "tcoil_master" "schematic" "tcoil3_mmw" "neo" "10" )
CCSchangeParam( "tcoil" "tcoil_master" "schematic" "tcoil3_mmw" "nei" "5" )
lxGenFromSource( cv_schematic )
cv_layout = dbOpenCellViewByType("tcoil" "tcoil_master" "layout")
MovePinsToInstances( cv_schematic cv_layout )
StreamOutGDS("tcoil" "tcoil_master" "layout" "/autofs/fs1.ece/fs1.eecg.tcc/lizongh2/gf22x-1020b/EMX_work/tcoil_tcoil2828.work" "tcoil2828.gds")

cv_schematic = dbOpenCellViewByType("tcoil" "tcoil_master" "schematic")
CCSchangeParam( "tcoil" "tcoil_master" "schematic" "tcoil3_mmw" "pneo" "60" )
CCSchangeParam( "tcoil" "tcoil_master" "schematic" "tcoil3_mmw" "ctapLocation" "bot" )
CCSchangeParam( "tcoil" "tcoil_master" "schematic" "tcoil3_mmw" "od" "68u" )
CCSchangeParam( "tcoil" "tcoil_master" "schematic" "tcoil3_mmw" "w" "5.0u" )
CCSchangeParam( "tcoil" "tcoil_master" "schematic" "tcoil3_mmw" "neo" "12" )
CCSchangeParam( "tcoil" "tcoil_master" "schematic" "tcoil3_mmw" "nei" "5" )
lxGenFromSource( cv_schematic )
cv_layout = dbOpenCellViewByType("tcoil" "tcoil_master" "layout")
MovePinsToInstances( cv_schematic cv_layout )
StreamOutGDS("tcoil" "tcoil_master" "layout" "/autofs/fs1.ece/fs1.eecg.tcc/lizongh2/gf22x-1020b/EMX_work/tcoil_tcoil2829.work" "tcoil2829.gds")

cv_schematic = dbOpenCellViewByType("tcoil" "tcoil_master" "schematic")
CCSchangeParam( "tcoil" "tcoil_master" "schematic" "tcoil3_mmw" "pneo" "60" )
CCSchangeParam( "tcoil" "tcoil_master" "schematic" "tcoil3_mmw" "ctapLocation" "bot" )
CCSchangeParam( "tcoil" "tcoil_master" "schematic" "tcoil3_mmw" "od" "70u" )
CCSchangeParam( "tcoil" "tcoil_master" "schematic" "tcoil3_mmw" "w" "2.4u" )
CCSchangeParam( "tcoil" "tcoil_master" "schematic" "tcoil3_mmw" "neo" "4" )
CCSchangeParam( "tcoil" "tcoil_master" "schematic" "tcoil3_mmw" "nei" "5" )
lxGenFromSource( cv_schematic )
cv_layout = dbOpenCellViewByType("tcoil" "tcoil_master" "layout")
MovePinsToInstances( cv_schematic cv_layout )
StreamOutGDS("tcoil" "tcoil_master" "layout" "/autofs/fs1.ece/fs1.eecg.tcc/lizongh2/gf22x-1020b/EMX_work/tcoil_tcoil2830.work" "tcoil2830.gds")

cv_schematic = dbOpenCellViewByType("tcoil" "tcoil_master" "schematic")
CCSchangeParam( "tcoil" "tcoil_master" "schematic" "tcoil3_mmw" "pneo" "60" )
CCSchangeParam( "tcoil" "tcoil_master" "schematic" "tcoil3_mmw" "ctapLocation" "bot" )
CCSchangeParam( "tcoil" "tcoil_master" "schematic" "tcoil3_mmw" "od" "70u" )
CCSchangeParam( "tcoil" "tcoil_master" "schematic" "tcoil3_mmw" "w" "2.4u" )
CCSchangeParam( "tcoil" "tcoil_master" "schematic" "tcoil3_mmw" "neo" "6" )
CCSchangeParam( "tcoil" "tcoil_master" "schematic" "tcoil3_mmw" "nei" "5" )
lxGenFromSource( cv_schematic )
cv_layout = dbOpenCellViewByType("tcoil" "tcoil_master" "layout")
MovePinsToInstances( cv_schematic cv_layout )
StreamOutGDS("tcoil" "tcoil_master" "layout" "/autofs/fs1.ece/fs1.eecg.tcc/lizongh2/gf22x-1020b/EMX_work/tcoil_tcoil2831.work" "tcoil2831.gds")

cv_schematic = dbOpenCellViewByType("tcoil" "tcoil_master" "schematic")
CCSchangeParam( "tcoil" "tcoil_master" "schematic" "tcoil3_mmw" "pneo" "60" )
CCSchangeParam( "tcoil" "tcoil_master" "schematic" "tcoil3_mmw" "ctapLocation" "bot" )
CCSchangeParam( "tcoil" "tcoil_master" "schematic" "tcoil3_mmw" "od" "70u" )
CCSchangeParam( "tcoil" "tcoil_master" "schematic" "tcoil3_mmw" "w" "2.4u" )
CCSchangeParam( "tcoil" "tcoil_master" "schematic" "tcoil3_mmw" "neo" "8" )
CCSchangeParam( "tcoil" "tcoil_master" "schematic" "tcoil3_mmw" "nei" "5" )
lxGenFromSource( cv_schematic )
cv_layout = dbOpenCellViewByType("tcoil" "tcoil_master" "layout")
MovePinsToInstances( cv_schematic cv_layout )
StreamOutGDS("tcoil" "tcoil_master" "layout" "/autofs/fs1.ece/fs1.eecg.tcc/lizongh2/gf22x-1020b/EMX_work/tcoil_tcoil2832.work" "tcoil2832.gds")

cv_schematic = dbOpenCellViewByType("tcoil" "tcoil_master" "schematic")
CCSchangeParam( "tcoil" "tcoil_master" "schematic" "tcoil3_mmw" "pneo" "60" )
CCSchangeParam( "tcoil" "tcoil_master" "schematic" "tcoil3_mmw" "ctapLocation" "bot" )
CCSchangeParam( "tcoil" "tcoil_master" "schematic" "tcoil3_mmw" "od" "70u" )
CCSchangeParam( "tcoil" "tcoil_master" "schematic" "tcoil3_mmw" "w" "2.4u" )
CCSchangeParam( "tcoil" "tcoil_master" "schematic" "tcoil3_mmw" "neo" "10" )
CCSchangeParam( "tcoil" "tcoil_master" "schematic" "tcoil3_mmw" "nei" "5" )
lxGenFromSource( cv_schematic )
cv_layout = dbOpenCellViewByType("tcoil" "tcoil_master" "layout")
MovePinsToInstances( cv_schematic cv_layout )
StreamOutGDS("tcoil" "tcoil_master" "layout" "/autofs/fs1.ece/fs1.eecg.tcc/lizongh2/gf22x-1020b/EMX_work/tcoil_tcoil2833.work" "tcoil2833.gds")

cv_schematic = dbOpenCellViewByType("tcoil" "tcoil_master" "schematic")
CCSchangeParam( "tcoil" "tcoil_master" "schematic" "tcoil3_mmw" "pneo" "60" )
CCSchangeParam( "tcoil" "tcoil_master" "schematic" "tcoil3_mmw" "ctapLocation" "bot" )
CCSchangeParam( "tcoil" "tcoil_master" "schematic" "tcoil3_mmw" "od" "70u" )
CCSchangeParam( "tcoil" "tcoil_master" "schematic" "tcoil3_mmw" "w" "2.4u" )
CCSchangeParam( "tcoil" "tcoil_master" "schematic" "tcoil3_mmw" "neo" "12" )
CCSchangeParam( "tcoil" "tcoil_master" "schematic" "tcoil3_mmw" "nei" "5" )
lxGenFromSource( cv_schematic )
cv_layout = dbOpenCellViewByType("tcoil" "tcoil_master" "layout")
MovePinsToInstances( cv_schematic cv_layout )
StreamOutGDS("tcoil" "tcoil_master" "layout" "/autofs/fs1.ece/fs1.eecg.tcc/lizongh2/gf22x-1020b/EMX_work/tcoil_tcoil2834.work" "tcoil2834.gds")

cv_schematic = dbOpenCellViewByType("tcoil" "tcoil_master" "schematic")
CCSchangeParam( "tcoil" "tcoil_master" "schematic" "tcoil3_mmw" "pneo" "60" )
CCSchangeParam( "tcoil" "tcoil_master" "schematic" "tcoil3_mmw" "ctapLocation" "bot" )
CCSchangeParam( "tcoil" "tcoil_master" "schematic" "tcoil3_mmw" "od" "70u" )
CCSchangeParam( "tcoil" "tcoil_master" "schematic" "tcoil3_mmw" "w" "4.2u" )
CCSchangeParam( "tcoil" "tcoil_master" "schematic" "tcoil3_mmw" "neo" "4" )
CCSchangeParam( "tcoil" "tcoil_master" "schematic" "tcoil3_mmw" "nei" "5" )
lxGenFromSource( cv_schematic )
cv_layout = dbOpenCellViewByType("tcoil" "tcoil_master" "layout")
MovePinsToInstances( cv_schematic cv_layout )
StreamOutGDS("tcoil" "tcoil_master" "layout" "/autofs/fs1.ece/fs1.eecg.tcc/lizongh2/gf22x-1020b/EMX_work/tcoil_tcoil2835.work" "tcoil2835.gds")

cv_schematic = dbOpenCellViewByType("tcoil" "tcoil_master" "schematic")
CCSchangeParam( "tcoil" "tcoil_master" "schematic" "tcoil3_mmw" "pneo" "60" )
CCSchangeParam( "tcoil" "tcoil_master" "schematic" "tcoil3_mmw" "ctapLocation" "bot" )
CCSchangeParam( "tcoil" "tcoil_master" "schematic" "tcoil3_mmw" "od" "70u" )
CCSchangeParam( "tcoil" "tcoil_master" "schematic" "tcoil3_mmw" "w" "4.2u" )
CCSchangeParam( "tcoil" "tcoil_master" "schematic" "tcoil3_mmw" "neo" "6" )
CCSchangeParam( "tcoil" "tcoil_master" "schematic" "tcoil3_mmw" "nei" "5" )
lxGenFromSource( cv_schematic )
cv_layout = dbOpenCellViewByType("tcoil" "tcoil_master" "layout")
MovePinsToInstances( cv_schematic cv_layout )
StreamOutGDS("tcoil" "tcoil_master" "layout" "/autofs/fs1.ece/fs1.eecg.tcc/lizongh2/gf22x-1020b/EMX_work/tcoil_tcoil2836.work" "tcoil2836.gds")

cv_schematic = dbOpenCellViewByType("tcoil" "tcoil_master" "schematic")
CCSchangeParam( "tcoil" "tcoil_master" "schematic" "tcoil3_mmw" "pneo" "60" )
CCSchangeParam( "tcoil" "tcoil_master" "schematic" "tcoil3_mmw" "ctapLocation" "bot" )
CCSchangeParam( "tcoil" "tcoil_master" "schematic" "tcoil3_mmw" "od" "70u" )
CCSchangeParam( "tcoil" "tcoil_master" "schematic" "tcoil3_mmw" "w" "4.2u" )
CCSchangeParam( "tcoil" "tcoil_master" "schematic" "tcoil3_mmw" "neo" "8" )
CCSchangeParam( "tcoil" "tcoil_master" "schematic" "tcoil3_mmw" "nei" "5" )
lxGenFromSource( cv_schematic )
cv_layout = dbOpenCellViewByType("tcoil" "tcoil_master" "layout")
MovePinsToInstances( cv_schematic cv_layout )
StreamOutGDS("tcoil" "tcoil_master" "layout" "/autofs/fs1.ece/fs1.eecg.tcc/lizongh2/gf22x-1020b/EMX_work/tcoil_tcoil2837.work" "tcoil2837.gds")

cv_schematic = dbOpenCellViewByType("tcoil" "tcoil_master" "schematic")
CCSchangeParam( "tcoil" "tcoil_master" "schematic" "tcoil3_mmw" "pneo" "60" )
CCSchangeParam( "tcoil" "tcoil_master" "schematic" "tcoil3_mmw" "ctapLocation" "bot" )
CCSchangeParam( "tcoil" "tcoil_master" "schematic" "tcoil3_mmw" "od" "70u" )
CCSchangeParam( "tcoil" "tcoil_master" "schematic" "tcoil3_mmw" "w" "4.2u" )
CCSchangeParam( "tcoil" "tcoil_master" "schematic" "tcoil3_mmw" "neo" "10" )
CCSchangeParam( "tcoil" "tcoil_master" "schematic" "tcoil3_mmw" "nei" "5" )
lxGenFromSource( cv_schematic )
cv_layout = dbOpenCellViewByType("tcoil" "tcoil_master" "layout")
MovePinsToInstances( cv_schematic cv_layout )
StreamOutGDS("tcoil" "tcoil_master" "layout" "/autofs/fs1.ece/fs1.eecg.tcc/lizongh2/gf22x-1020b/EMX_work/tcoil_tcoil2838.work" "tcoil2838.gds")

cv_schematic = dbOpenCellViewByType("tcoil" "tcoil_master" "schematic")
CCSchangeParam( "tcoil" "tcoil_master" "schematic" "tcoil3_mmw" "pneo" "60" )
CCSchangeParam( "tcoil" "tcoil_master" "schematic" "tcoil3_mmw" "ctapLocation" "bot" )
CCSchangeParam( "tcoil" "tcoil_master" "schematic" "tcoil3_mmw" "od" "70u" )
CCSchangeParam( "tcoil" "tcoil_master" "schematic" "tcoil3_mmw" "w" "4.2u" )
CCSchangeParam( "tcoil" "tcoil_master" "schematic" "tcoil3_mmw" "neo" "12" )
CCSchangeParam( "tcoil" "tcoil_master" "schematic" "tcoil3_mmw" "nei" "5" )
lxGenFromSource( cv_schematic )
cv_layout = dbOpenCellViewByType("tcoil" "tcoil_master" "layout")
MovePinsToInstances( cv_schematic cv_layout )
StreamOutGDS("tcoil" "tcoil_master" "layout" "/autofs/fs1.ece/fs1.eecg.tcc/lizongh2/gf22x-1020b/EMX_work/tcoil_tcoil2839.work" "tcoil2839.gds")

cv_schematic = dbOpenCellViewByType("tcoil" "tcoil_master" "schematic")
CCSchangeParam( "tcoil" "tcoil_master" "schematic" "tcoil3_mmw" "pneo" "60" )
CCSchangeParam( "tcoil" "tcoil_master" "schematic" "tcoil3_mmw" "ctapLocation" "bot" )
CCSchangeParam( "tcoil" "tcoil_master" "schematic" "tcoil3_mmw" "od" "70u" )
CCSchangeParam( "tcoil" "tcoil_master" "schematic" "tcoil3_mmw" "w" "5.0u" )
CCSchangeParam( "tcoil" "tcoil_master" "schematic" "tcoil3_mmw" "neo" "4" )
CCSchangeParam( "tcoil" "tcoil_master" "schematic" "tcoil3_mmw" "nei" "5" )
lxGenFromSource( cv_schematic )
cv_layout = dbOpenCellViewByType("tcoil" "tcoil_master" "layout")
MovePinsToInstances( cv_schematic cv_layout )
StreamOutGDS("tcoil" "tcoil_master" "layout" "/autofs/fs1.ece/fs1.eecg.tcc/lizongh2/gf22x-1020b/EMX_work/tcoil_tcoil2840.work" "tcoil2840.gds")

cv_schematic = dbOpenCellViewByType("tcoil" "tcoil_master" "schematic")
CCSchangeParam( "tcoil" "tcoil_master" "schematic" "tcoil3_mmw" "pneo" "60" )
CCSchangeParam( "tcoil" "tcoil_master" "schematic" "tcoil3_mmw" "ctapLocation" "bot" )
CCSchangeParam( "tcoil" "tcoil_master" "schematic" "tcoil3_mmw" "od" "70u" )
CCSchangeParam( "tcoil" "tcoil_master" "schematic" "tcoil3_mmw" "w" "5.0u" )
CCSchangeParam( "tcoil" "tcoil_master" "schematic" "tcoil3_mmw" "neo" "6" )
CCSchangeParam( "tcoil" "tcoil_master" "schematic" "tcoil3_mmw" "nei" "5" )
lxGenFromSource( cv_schematic )
cv_layout = dbOpenCellViewByType("tcoil" "tcoil_master" "layout")
MovePinsToInstances( cv_schematic cv_layout )
StreamOutGDS("tcoil" "tcoil_master" "layout" "/autofs/fs1.ece/fs1.eecg.tcc/lizongh2/gf22x-1020b/EMX_work/tcoil_tcoil2841.work" "tcoil2841.gds")

cv_schematic = dbOpenCellViewByType("tcoil" "tcoil_master" "schematic")
CCSchangeParam( "tcoil" "tcoil_master" "schematic" "tcoil3_mmw" "pneo" "60" )
CCSchangeParam( "tcoil" "tcoil_master" "schematic" "tcoil3_mmw" "ctapLocation" "bot" )
CCSchangeParam( "tcoil" "tcoil_master" "schematic" "tcoil3_mmw" "od" "70u" )
CCSchangeParam( "tcoil" "tcoil_master" "schematic" "tcoil3_mmw" "w" "5.0u" )
CCSchangeParam( "tcoil" "tcoil_master" "schematic" "tcoil3_mmw" "neo" "8" )
CCSchangeParam( "tcoil" "tcoil_master" "schematic" "tcoil3_mmw" "nei" "5" )
lxGenFromSource( cv_schematic )
cv_layout = dbOpenCellViewByType("tcoil" "tcoil_master" "layout")
MovePinsToInstances( cv_schematic cv_layout )
StreamOutGDS("tcoil" "tcoil_master" "layout" "/autofs/fs1.ece/fs1.eecg.tcc/lizongh2/gf22x-1020b/EMX_work/tcoil_tcoil2842.work" "tcoil2842.gds")

cv_schematic = dbOpenCellViewByType("tcoil" "tcoil_master" "schematic")
CCSchangeParam( "tcoil" "tcoil_master" "schematic" "tcoil3_mmw" "pneo" "60" )
CCSchangeParam( "tcoil" "tcoil_master" "schematic" "tcoil3_mmw" "ctapLocation" "bot" )
CCSchangeParam( "tcoil" "tcoil_master" "schematic" "tcoil3_mmw" "od" "70u" )
CCSchangeParam( "tcoil" "tcoil_master" "schematic" "tcoil3_mmw" "w" "5.0u" )
CCSchangeParam( "tcoil" "tcoil_master" "schematic" "tcoil3_mmw" "neo" "10" )
CCSchangeParam( "tcoil" "tcoil_master" "schematic" "tcoil3_mmw" "nei" "5" )
lxGenFromSource( cv_schematic )
cv_layout = dbOpenCellViewByType("tcoil" "tcoil_master" "layout")
MovePinsToInstances( cv_schematic cv_layout )
StreamOutGDS("tcoil" "tcoil_master" "layout" "/autofs/fs1.ece/fs1.eecg.tcc/lizongh2/gf22x-1020b/EMX_work/tcoil_tcoil2843.work" "tcoil2843.gds")

cv_schematic = dbOpenCellViewByType("tcoil" "tcoil_master" "schematic")
CCSchangeParam( "tcoil" "tcoil_master" "schematic" "tcoil3_mmw" "pneo" "60" )
CCSchangeParam( "tcoil" "tcoil_master" "schematic" "tcoil3_mmw" "ctapLocation" "bot" )
CCSchangeParam( "tcoil" "tcoil_master" "schematic" "tcoil3_mmw" "od" "70u" )
CCSchangeParam( "tcoil" "tcoil_master" "schematic" "tcoil3_mmw" "w" "5.0u" )
CCSchangeParam( "tcoil" "tcoil_master" "schematic" "tcoil3_mmw" "neo" "12" )
CCSchangeParam( "tcoil" "tcoil_master" "schematic" "tcoil3_mmw" "nei" "5" )
lxGenFromSource( cv_schematic )
cv_layout = dbOpenCellViewByType("tcoil" "tcoil_master" "layout")
MovePinsToInstances( cv_schematic cv_layout )
StreamOutGDS("tcoil" "tcoil_master" "layout" "/autofs/fs1.ece/fs1.eecg.tcc/lizongh2/gf22x-1020b/EMX_work/tcoil_tcoil2844.work" "tcoil2844.gds")

cv_schematic = dbOpenCellViewByType("tcoil" "tcoil_master" "schematic")
CCSchangeParam( "tcoil" "tcoil_master" "schematic" "tcoil3_mmw" "pneo" "60" )
CCSchangeParam( "tcoil" "tcoil_master" "schematic" "tcoil3_mmw" "ctapLocation" "bot" )
CCSchangeParam( "tcoil" "tcoil_master" "schematic" "tcoil3_mmw" "od" "72u" )
CCSchangeParam( "tcoil" "tcoil_master" "schematic" "tcoil3_mmw" "w" "2.4u" )
CCSchangeParam( "tcoil" "tcoil_master" "schematic" "tcoil3_mmw" "neo" "4" )
CCSchangeParam( "tcoil" "tcoil_master" "schematic" "tcoil3_mmw" "nei" "5" )
lxGenFromSource( cv_schematic )
cv_layout = dbOpenCellViewByType("tcoil" "tcoil_master" "layout")
MovePinsToInstances( cv_schematic cv_layout )
StreamOutGDS("tcoil" "tcoil_master" "layout" "/autofs/fs1.ece/fs1.eecg.tcc/lizongh2/gf22x-1020b/EMX_work/tcoil_tcoil2845.work" "tcoil2845.gds")

cv_schematic = dbOpenCellViewByType("tcoil" "tcoil_master" "schematic")
CCSchangeParam( "tcoil" "tcoil_master" "schematic" "tcoil3_mmw" "pneo" "60" )
CCSchangeParam( "tcoil" "tcoil_master" "schematic" "tcoil3_mmw" "ctapLocation" "bot" )
CCSchangeParam( "tcoil" "tcoil_master" "schematic" "tcoil3_mmw" "od" "72u" )
CCSchangeParam( "tcoil" "tcoil_master" "schematic" "tcoil3_mmw" "w" "2.4u" )
CCSchangeParam( "tcoil" "tcoil_master" "schematic" "tcoil3_mmw" "neo" "6" )
CCSchangeParam( "tcoil" "tcoil_master" "schematic" "tcoil3_mmw" "nei" "5" )
lxGenFromSource( cv_schematic )
cv_layout = dbOpenCellViewByType("tcoil" "tcoil_master" "layout")
MovePinsToInstances( cv_schematic cv_layout )
StreamOutGDS("tcoil" "tcoil_master" "layout" "/autofs/fs1.ece/fs1.eecg.tcc/lizongh2/gf22x-1020b/EMX_work/tcoil_tcoil2846.work" "tcoil2846.gds")

cv_schematic = dbOpenCellViewByType("tcoil" "tcoil_master" "schematic")
CCSchangeParam( "tcoil" "tcoil_master" "schematic" "tcoil3_mmw" "pneo" "60" )
CCSchangeParam( "tcoil" "tcoil_master" "schematic" "tcoil3_mmw" "ctapLocation" "bot" )
CCSchangeParam( "tcoil" "tcoil_master" "schematic" "tcoil3_mmw" "od" "72u" )
CCSchangeParam( "tcoil" "tcoil_master" "schematic" "tcoil3_mmw" "w" "2.4u" )
CCSchangeParam( "tcoil" "tcoil_master" "schematic" "tcoil3_mmw" "neo" "8" )
CCSchangeParam( "tcoil" "tcoil_master" "schematic" "tcoil3_mmw" "nei" "5" )
lxGenFromSource( cv_schematic )
cv_layout = dbOpenCellViewByType("tcoil" "tcoil_master" "layout")
MovePinsToInstances( cv_schematic cv_layout )
StreamOutGDS("tcoil" "tcoil_master" "layout" "/autofs/fs1.ece/fs1.eecg.tcc/lizongh2/gf22x-1020b/EMX_work/tcoil_tcoil2847.work" "tcoil2847.gds")

cv_schematic = dbOpenCellViewByType("tcoil" "tcoil_master" "schematic")
CCSchangeParam( "tcoil" "tcoil_master" "schematic" "tcoil3_mmw" "pneo" "60" )
CCSchangeParam( "tcoil" "tcoil_master" "schematic" "tcoil3_mmw" "ctapLocation" "bot" )
CCSchangeParam( "tcoil" "tcoil_master" "schematic" "tcoil3_mmw" "od" "72u" )
CCSchangeParam( "tcoil" "tcoil_master" "schematic" "tcoil3_mmw" "w" "2.4u" )
CCSchangeParam( "tcoil" "tcoil_master" "schematic" "tcoil3_mmw" "neo" "10" )
CCSchangeParam( "tcoil" "tcoil_master" "schematic" "tcoil3_mmw" "nei" "5" )
lxGenFromSource( cv_schematic )
cv_layout = dbOpenCellViewByType("tcoil" "tcoil_master" "layout")
MovePinsToInstances( cv_schematic cv_layout )
StreamOutGDS("tcoil" "tcoil_master" "layout" "/autofs/fs1.ece/fs1.eecg.tcc/lizongh2/gf22x-1020b/EMX_work/tcoil_tcoil2848.work" "tcoil2848.gds")

cv_schematic = dbOpenCellViewByType("tcoil" "tcoil_master" "schematic")
CCSchangeParam( "tcoil" "tcoil_master" "schematic" "tcoil3_mmw" "pneo" "60" )
CCSchangeParam( "tcoil" "tcoil_master" "schematic" "tcoil3_mmw" "ctapLocation" "bot" )
CCSchangeParam( "tcoil" "tcoil_master" "schematic" "tcoil3_mmw" "od" "72u" )
CCSchangeParam( "tcoil" "tcoil_master" "schematic" "tcoil3_mmw" "w" "2.4u" )
CCSchangeParam( "tcoil" "tcoil_master" "schematic" "tcoil3_mmw" "neo" "12" )
CCSchangeParam( "tcoil" "tcoil_master" "schematic" "tcoil3_mmw" "nei" "5" )
lxGenFromSource( cv_schematic )
cv_layout = dbOpenCellViewByType("tcoil" "tcoil_master" "layout")
MovePinsToInstances( cv_schematic cv_layout )
StreamOutGDS("tcoil" "tcoil_master" "layout" "/autofs/fs1.ece/fs1.eecg.tcc/lizongh2/gf22x-1020b/EMX_work/tcoil_tcoil2849.work" "tcoil2849.gds")

cv_schematic = dbOpenCellViewByType("tcoil" "tcoil_master" "schematic")
CCSchangeParam( "tcoil" "tcoil_master" "schematic" "tcoil3_mmw" "pneo" "60" )
CCSchangeParam( "tcoil" "tcoil_master" "schematic" "tcoil3_mmw" "ctapLocation" "bot" )
CCSchangeParam( "tcoil" "tcoil_master" "schematic" "tcoil3_mmw" "od" "72u" )
CCSchangeParam( "tcoil" "tcoil_master" "schematic" "tcoil3_mmw" "w" "4.2u" )
CCSchangeParam( "tcoil" "tcoil_master" "schematic" "tcoil3_mmw" "neo" "4" )
CCSchangeParam( "tcoil" "tcoil_master" "schematic" "tcoil3_mmw" "nei" "5" )
lxGenFromSource( cv_schematic )
cv_layout = dbOpenCellViewByType("tcoil" "tcoil_master" "layout")
MovePinsToInstances( cv_schematic cv_layout )
StreamOutGDS("tcoil" "tcoil_master" "layout" "/autofs/fs1.ece/fs1.eecg.tcc/lizongh2/gf22x-1020b/EMX_work/tcoil_tcoil2850.work" "tcoil2850.gds")

cv_schematic = dbOpenCellViewByType("tcoil" "tcoil_master" "schematic")
CCSchangeParam( "tcoil" "tcoil_master" "schematic" "tcoil3_mmw" "pneo" "60" )
CCSchangeParam( "tcoil" "tcoil_master" "schematic" "tcoil3_mmw" "ctapLocation" "bot" )
CCSchangeParam( "tcoil" "tcoil_master" "schematic" "tcoil3_mmw" "od" "72u" )
CCSchangeParam( "tcoil" "tcoil_master" "schematic" "tcoil3_mmw" "w" "4.2u" )
CCSchangeParam( "tcoil" "tcoil_master" "schematic" "tcoil3_mmw" "neo" "6" )
CCSchangeParam( "tcoil" "tcoil_master" "schematic" "tcoil3_mmw" "nei" "5" )
lxGenFromSource( cv_schematic )
cv_layout = dbOpenCellViewByType("tcoil" "tcoil_master" "layout")
MovePinsToInstances( cv_schematic cv_layout )
StreamOutGDS("tcoil" "tcoil_master" "layout" "/autofs/fs1.ece/fs1.eecg.tcc/lizongh2/gf22x-1020b/EMX_work/tcoil_tcoil2851.work" "tcoil2851.gds")

cv_schematic = dbOpenCellViewByType("tcoil" "tcoil_master" "schematic")
CCSchangeParam( "tcoil" "tcoil_master" "schematic" "tcoil3_mmw" "pneo" "60" )
CCSchangeParam( "tcoil" "tcoil_master" "schematic" "tcoil3_mmw" "ctapLocation" "bot" )
CCSchangeParam( "tcoil" "tcoil_master" "schematic" "tcoil3_mmw" "od" "72u" )
CCSchangeParam( "tcoil" "tcoil_master" "schematic" "tcoil3_mmw" "w" "4.2u" )
CCSchangeParam( "tcoil" "tcoil_master" "schematic" "tcoil3_mmw" "neo" "8" )
CCSchangeParam( "tcoil" "tcoil_master" "schematic" "tcoil3_mmw" "nei" "5" )
lxGenFromSource( cv_schematic )
cv_layout = dbOpenCellViewByType("tcoil" "tcoil_master" "layout")
MovePinsToInstances( cv_schematic cv_layout )
StreamOutGDS("tcoil" "tcoil_master" "layout" "/autofs/fs1.ece/fs1.eecg.tcc/lizongh2/gf22x-1020b/EMX_work/tcoil_tcoil2852.work" "tcoil2852.gds")

cv_schematic = dbOpenCellViewByType("tcoil" "tcoil_master" "schematic")
CCSchangeParam( "tcoil" "tcoil_master" "schematic" "tcoil3_mmw" "pneo" "60" )
CCSchangeParam( "tcoil" "tcoil_master" "schematic" "tcoil3_mmw" "ctapLocation" "bot" )
CCSchangeParam( "tcoil" "tcoil_master" "schematic" "tcoil3_mmw" "od" "72u" )
CCSchangeParam( "tcoil" "tcoil_master" "schematic" "tcoil3_mmw" "w" "4.2u" )
CCSchangeParam( "tcoil" "tcoil_master" "schematic" "tcoil3_mmw" "neo" "10" )
CCSchangeParam( "tcoil" "tcoil_master" "schematic" "tcoil3_mmw" "nei" "5" )
lxGenFromSource( cv_schematic )
cv_layout = dbOpenCellViewByType("tcoil" "tcoil_master" "layout")
MovePinsToInstances( cv_schematic cv_layout )
StreamOutGDS("tcoil" "tcoil_master" "layout" "/autofs/fs1.ece/fs1.eecg.tcc/lizongh2/gf22x-1020b/EMX_work/tcoil_tcoil2853.work" "tcoil2853.gds")

cv_schematic = dbOpenCellViewByType("tcoil" "tcoil_master" "schematic")
CCSchangeParam( "tcoil" "tcoil_master" "schematic" "tcoil3_mmw" "pneo" "60" )
CCSchangeParam( "tcoil" "tcoil_master" "schematic" "tcoil3_mmw" "ctapLocation" "bot" )
CCSchangeParam( "tcoil" "tcoil_master" "schematic" "tcoil3_mmw" "od" "72u" )
CCSchangeParam( "tcoil" "tcoil_master" "schematic" "tcoil3_mmw" "w" "4.2u" )
CCSchangeParam( "tcoil" "tcoil_master" "schematic" "tcoil3_mmw" "neo" "12" )
CCSchangeParam( "tcoil" "tcoil_master" "schematic" "tcoil3_mmw" "nei" "5" )
lxGenFromSource( cv_schematic )
cv_layout = dbOpenCellViewByType("tcoil" "tcoil_master" "layout")
MovePinsToInstances( cv_schematic cv_layout )
StreamOutGDS("tcoil" "tcoil_master" "layout" "/autofs/fs1.ece/fs1.eecg.tcc/lizongh2/gf22x-1020b/EMX_work/tcoil_tcoil2854.work" "tcoil2854.gds")

cv_schematic = dbOpenCellViewByType("tcoil" "tcoil_master" "schematic")
CCSchangeParam( "tcoil" "tcoil_master" "schematic" "tcoil3_mmw" "pneo" "60" )
CCSchangeParam( "tcoil" "tcoil_master" "schematic" "tcoil3_mmw" "ctapLocation" "bot" )
CCSchangeParam( "tcoil" "tcoil_master" "schematic" "tcoil3_mmw" "od" "72u" )
CCSchangeParam( "tcoil" "tcoil_master" "schematic" "tcoil3_mmw" "w" "5.0u" )
CCSchangeParam( "tcoil" "tcoil_master" "schematic" "tcoil3_mmw" "neo" "4" )
CCSchangeParam( "tcoil" "tcoil_master" "schematic" "tcoil3_mmw" "nei" "5" )
lxGenFromSource( cv_schematic )
cv_layout = dbOpenCellViewByType("tcoil" "tcoil_master" "layout")
MovePinsToInstances( cv_schematic cv_layout )
StreamOutGDS("tcoil" "tcoil_master" "layout" "/autofs/fs1.ece/fs1.eecg.tcc/lizongh2/gf22x-1020b/EMX_work/tcoil_tcoil2855.work" "tcoil2855.gds")

cv_schematic = dbOpenCellViewByType("tcoil" "tcoil_master" "schematic")
CCSchangeParam( "tcoil" "tcoil_master" "schematic" "tcoil3_mmw" "pneo" "60" )
CCSchangeParam( "tcoil" "tcoil_master" "schematic" "tcoil3_mmw" "ctapLocation" "bot" )
CCSchangeParam( "tcoil" "tcoil_master" "schematic" "tcoil3_mmw" "od" "72u" )
CCSchangeParam( "tcoil" "tcoil_master" "schematic" "tcoil3_mmw" "w" "5.0u" )
CCSchangeParam( "tcoil" "tcoil_master" "schematic" "tcoil3_mmw" "neo" "6" )
CCSchangeParam( "tcoil" "tcoil_master" "schematic" "tcoil3_mmw" "nei" "5" )
lxGenFromSource( cv_schematic )
cv_layout = dbOpenCellViewByType("tcoil" "tcoil_master" "layout")
MovePinsToInstances( cv_schematic cv_layout )
StreamOutGDS("tcoil" "tcoil_master" "layout" "/autofs/fs1.ece/fs1.eecg.tcc/lizongh2/gf22x-1020b/EMX_work/tcoil_tcoil2856.work" "tcoil2856.gds")

cv_schematic = dbOpenCellViewByType("tcoil" "tcoil_master" "schematic")
CCSchangeParam( "tcoil" "tcoil_master" "schematic" "tcoil3_mmw" "pneo" "60" )
CCSchangeParam( "tcoil" "tcoil_master" "schematic" "tcoil3_mmw" "ctapLocation" "bot" )
CCSchangeParam( "tcoil" "tcoil_master" "schematic" "tcoil3_mmw" "od" "72u" )
CCSchangeParam( "tcoil" "tcoil_master" "schematic" "tcoil3_mmw" "w" "5.0u" )
CCSchangeParam( "tcoil" "tcoil_master" "schematic" "tcoil3_mmw" "neo" "8" )
CCSchangeParam( "tcoil" "tcoil_master" "schematic" "tcoil3_mmw" "nei" "5" )
lxGenFromSource( cv_schematic )
cv_layout = dbOpenCellViewByType("tcoil" "tcoil_master" "layout")
MovePinsToInstances( cv_schematic cv_layout )
StreamOutGDS("tcoil" "tcoil_master" "layout" "/autofs/fs1.ece/fs1.eecg.tcc/lizongh2/gf22x-1020b/EMX_work/tcoil_tcoil2857.work" "tcoil2857.gds")

cv_schematic = dbOpenCellViewByType("tcoil" "tcoil_master" "schematic")
CCSchangeParam( "tcoil" "tcoil_master" "schematic" "tcoil3_mmw" "pneo" "60" )
CCSchangeParam( "tcoil" "tcoil_master" "schematic" "tcoil3_mmw" "ctapLocation" "bot" )
CCSchangeParam( "tcoil" "tcoil_master" "schematic" "tcoil3_mmw" "od" "72u" )
CCSchangeParam( "tcoil" "tcoil_master" "schematic" "tcoil3_mmw" "w" "5.0u" )
CCSchangeParam( "tcoil" "tcoil_master" "schematic" "tcoil3_mmw" "neo" "10" )
CCSchangeParam( "tcoil" "tcoil_master" "schematic" "tcoil3_mmw" "nei" "5" )
lxGenFromSource( cv_schematic )
cv_layout = dbOpenCellViewByType("tcoil" "tcoil_master" "layout")
MovePinsToInstances( cv_schematic cv_layout )
StreamOutGDS("tcoil" "tcoil_master" "layout" "/autofs/fs1.ece/fs1.eecg.tcc/lizongh2/gf22x-1020b/EMX_work/tcoil_tcoil2858.work" "tcoil2858.gds")

cv_schematic = dbOpenCellViewByType("tcoil" "tcoil_master" "schematic")
CCSchangeParam( "tcoil" "tcoil_master" "schematic" "tcoil3_mmw" "pneo" "60" )
CCSchangeParam( "tcoil" "tcoil_master" "schematic" "tcoil3_mmw" "ctapLocation" "bot" )
CCSchangeParam( "tcoil" "tcoil_master" "schematic" "tcoil3_mmw" "od" "72u" )
CCSchangeParam( "tcoil" "tcoil_master" "schematic" "tcoil3_mmw" "w" "5.0u" )
CCSchangeParam( "tcoil" "tcoil_master" "schematic" "tcoil3_mmw" "neo" "12" )
CCSchangeParam( "tcoil" "tcoil_master" "schematic" "tcoil3_mmw" "nei" "5" )
lxGenFromSource( cv_schematic )
cv_layout = dbOpenCellViewByType("tcoil" "tcoil_master" "layout")
MovePinsToInstances( cv_schematic cv_layout )
StreamOutGDS("tcoil" "tcoil_master" "layout" "/autofs/fs1.ece/fs1.eecg.tcc/lizongh2/gf22x-1020b/EMX_work/tcoil_tcoil2859.work" "tcoil2859.gds")

cv_schematic = dbOpenCellViewByType("tcoil" "tcoil_master" "schematic")
CCSchangeParam( "tcoil" "tcoil_master" "schematic" "tcoil3_mmw" "pneo" "60" )
CCSchangeParam( "tcoil" "tcoil_master" "schematic" "tcoil3_mmw" "ctapLocation" "bot" )
CCSchangeParam( "tcoil" "tcoil_master" "schematic" "tcoil3_mmw" "od" "74u" )
CCSchangeParam( "tcoil" "tcoil_master" "schematic" "tcoil3_mmw" "w" "2.4u" )
CCSchangeParam( "tcoil" "tcoil_master" "schematic" "tcoil3_mmw" "neo" "4" )
CCSchangeParam( "tcoil" "tcoil_master" "schematic" "tcoil3_mmw" "nei" "5" )
lxGenFromSource( cv_schematic )
cv_layout = dbOpenCellViewByType("tcoil" "tcoil_master" "layout")
MovePinsToInstances( cv_schematic cv_layout )
StreamOutGDS("tcoil" "tcoil_master" "layout" "/autofs/fs1.ece/fs1.eecg.tcc/lizongh2/gf22x-1020b/EMX_work/tcoil_tcoil2860.work" "tcoil2860.gds")

cv_schematic = dbOpenCellViewByType("tcoil" "tcoil_master" "schematic")
CCSchangeParam( "tcoil" "tcoil_master" "schematic" "tcoil3_mmw" "pneo" "60" )
CCSchangeParam( "tcoil" "tcoil_master" "schematic" "tcoil3_mmw" "ctapLocation" "bot" )
CCSchangeParam( "tcoil" "tcoil_master" "schematic" "tcoil3_mmw" "od" "74u" )
CCSchangeParam( "tcoil" "tcoil_master" "schematic" "tcoil3_mmw" "w" "2.4u" )
CCSchangeParam( "tcoil" "tcoil_master" "schematic" "tcoil3_mmw" "neo" "6" )
CCSchangeParam( "tcoil" "tcoil_master" "schematic" "tcoil3_mmw" "nei" "5" )
lxGenFromSource( cv_schematic )
cv_layout = dbOpenCellViewByType("tcoil" "tcoil_master" "layout")
MovePinsToInstances( cv_schematic cv_layout )
StreamOutGDS("tcoil" "tcoil_master" "layout" "/autofs/fs1.ece/fs1.eecg.tcc/lizongh2/gf22x-1020b/EMX_work/tcoil_tcoil2861.work" "tcoil2861.gds")

cv_schematic = dbOpenCellViewByType("tcoil" "tcoil_master" "schematic")
CCSchangeParam( "tcoil" "tcoil_master" "schematic" "tcoil3_mmw" "pneo" "60" )
CCSchangeParam( "tcoil" "tcoil_master" "schematic" "tcoil3_mmw" "ctapLocation" "bot" )
CCSchangeParam( "tcoil" "tcoil_master" "schematic" "tcoil3_mmw" "od" "74u" )
CCSchangeParam( "tcoil" "tcoil_master" "schematic" "tcoil3_mmw" "w" "2.4u" )
CCSchangeParam( "tcoil" "tcoil_master" "schematic" "tcoil3_mmw" "neo" "8" )
CCSchangeParam( "tcoil" "tcoil_master" "schematic" "tcoil3_mmw" "nei" "5" )
lxGenFromSource( cv_schematic )
cv_layout = dbOpenCellViewByType("tcoil" "tcoil_master" "layout")
MovePinsToInstances( cv_schematic cv_layout )
StreamOutGDS("tcoil" "tcoil_master" "layout" "/autofs/fs1.ece/fs1.eecg.tcc/lizongh2/gf22x-1020b/EMX_work/tcoil_tcoil2862.work" "tcoil2862.gds")

cv_schematic = dbOpenCellViewByType("tcoil" "tcoil_master" "schematic")
CCSchangeParam( "tcoil" "tcoil_master" "schematic" "tcoil3_mmw" "pneo" "60" )
CCSchangeParam( "tcoil" "tcoil_master" "schematic" "tcoil3_mmw" "ctapLocation" "bot" )
CCSchangeParam( "tcoil" "tcoil_master" "schematic" "tcoil3_mmw" "od" "74u" )
CCSchangeParam( "tcoil" "tcoil_master" "schematic" "tcoil3_mmw" "w" "2.4u" )
CCSchangeParam( "tcoil" "tcoil_master" "schematic" "tcoil3_mmw" "neo" "10" )
CCSchangeParam( "tcoil" "tcoil_master" "schematic" "tcoil3_mmw" "nei" "5" )
lxGenFromSource( cv_schematic )
cv_layout = dbOpenCellViewByType("tcoil" "tcoil_master" "layout")
MovePinsToInstances( cv_schematic cv_layout )
StreamOutGDS("tcoil" "tcoil_master" "layout" "/autofs/fs1.ece/fs1.eecg.tcc/lizongh2/gf22x-1020b/EMX_work/tcoil_tcoil2863.work" "tcoil2863.gds")

cv_schematic = dbOpenCellViewByType("tcoil" "tcoil_master" "schematic")
CCSchangeParam( "tcoil" "tcoil_master" "schematic" "tcoil3_mmw" "pneo" "60" )
CCSchangeParam( "tcoil" "tcoil_master" "schematic" "tcoil3_mmw" "ctapLocation" "bot" )
CCSchangeParam( "tcoil" "tcoil_master" "schematic" "tcoil3_mmw" "od" "74u" )
CCSchangeParam( "tcoil" "tcoil_master" "schematic" "tcoil3_mmw" "w" "2.4u" )
CCSchangeParam( "tcoil" "tcoil_master" "schematic" "tcoil3_mmw" "neo" "12" )
CCSchangeParam( "tcoil" "tcoil_master" "schematic" "tcoil3_mmw" "nei" "5" )
lxGenFromSource( cv_schematic )
cv_layout = dbOpenCellViewByType("tcoil" "tcoil_master" "layout")
MovePinsToInstances( cv_schematic cv_layout )
StreamOutGDS("tcoil" "tcoil_master" "layout" "/autofs/fs1.ece/fs1.eecg.tcc/lizongh2/gf22x-1020b/EMX_work/tcoil_tcoil2864.work" "tcoil2864.gds")

cv_schematic = dbOpenCellViewByType("tcoil" "tcoil_master" "schematic")
CCSchangeParam( "tcoil" "tcoil_master" "schematic" "tcoil3_mmw" "pneo" "60" )
CCSchangeParam( "tcoil" "tcoil_master" "schematic" "tcoil3_mmw" "ctapLocation" "bot" )
CCSchangeParam( "tcoil" "tcoil_master" "schematic" "tcoil3_mmw" "od" "74u" )
CCSchangeParam( "tcoil" "tcoil_master" "schematic" "tcoil3_mmw" "w" "4.2u" )
CCSchangeParam( "tcoil" "tcoil_master" "schematic" "tcoil3_mmw" "neo" "4" )
CCSchangeParam( "tcoil" "tcoil_master" "schematic" "tcoil3_mmw" "nei" "5" )
lxGenFromSource( cv_schematic )
cv_layout = dbOpenCellViewByType("tcoil" "tcoil_master" "layout")
MovePinsToInstances( cv_schematic cv_layout )
StreamOutGDS("tcoil" "tcoil_master" "layout" "/autofs/fs1.ece/fs1.eecg.tcc/lizongh2/gf22x-1020b/EMX_work/tcoil_tcoil2865.work" "tcoil2865.gds")

cv_schematic = dbOpenCellViewByType("tcoil" "tcoil_master" "schematic")
CCSchangeParam( "tcoil" "tcoil_master" "schematic" "tcoil3_mmw" "pneo" "60" )
CCSchangeParam( "tcoil" "tcoil_master" "schematic" "tcoil3_mmw" "ctapLocation" "bot" )
CCSchangeParam( "tcoil" "tcoil_master" "schematic" "tcoil3_mmw" "od" "74u" )
CCSchangeParam( "tcoil" "tcoil_master" "schematic" "tcoil3_mmw" "w" "4.2u" )
CCSchangeParam( "tcoil" "tcoil_master" "schematic" "tcoil3_mmw" "neo" "6" )
CCSchangeParam( "tcoil" "tcoil_master" "schematic" "tcoil3_mmw" "nei" "5" )
lxGenFromSource( cv_schematic )
cv_layout = dbOpenCellViewByType("tcoil" "tcoil_master" "layout")
MovePinsToInstances( cv_schematic cv_layout )
StreamOutGDS("tcoil" "tcoil_master" "layout" "/autofs/fs1.ece/fs1.eecg.tcc/lizongh2/gf22x-1020b/EMX_work/tcoil_tcoil2866.work" "tcoil2866.gds")

cv_schematic = dbOpenCellViewByType("tcoil" "tcoil_master" "schematic")
CCSchangeParam( "tcoil" "tcoil_master" "schematic" "tcoil3_mmw" "pneo" "60" )
CCSchangeParam( "tcoil" "tcoil_master" "schematic" "tcoil3_mmw" "ctapLocation" "bot" )
CCSchangeParam( "tcoil" "tcoil_master" "schematic" "tcoil3_mmw" "od" "74u" )
CCSchangeParam( "tcoil" "tcoil_master" "schematic" "tcoil3_mmw" "w" "4.2u" )
CCSchangeParam( "tcoil" "tcoil_master" "schematic" "tcoil3_mmw" "neo" "8" )
CCSchangeParam( "tcoil" "tcoil_master" "schematic" "tcoil3_mmw" "nei" "5" )
lxGenFromSource( cv_schematic )
cv_layout = dbOpenCellViewByType("tcoil" "tcoil_master" "layout")
MovePinsToInstances( cv_schematic cv_layout )
StreamOutGDS("tcoil" "tcoil_master" "layout" "/autofs/fs1.ece/fs1.eecg.tcc/lizongh2/gf22x-1020b/EMX_work/tcoil_tcoil2867.work" "tcoil2867.gds")

cv_schematic = dbOpenCellViewByType("tcoil" "tcoil_master" "schematic")
CCSchangeParam( "tcoil" "tcoil_master" "schematic" "tcoil3_mmw" "pneo" "60" )
CCSchangeParam( "tcoil" "tcoil_master" "schematic" "tcoil3_mmw" "ctapLocation" "bot" )
CCSchangeParam( "tcoil" "tcoil_master" "schematic" "tcoil3_mmw" "od" "74u" )
CCSchangeParam( "tcoil" "tcoil_master" "schematic" "tcoil3_mmw" "w" "4.2u" )
CCSchangeParam( "tcoil" "tcoil_master" "schematic" "tcoil3_mmw" "neo" "10" )
CCSchangeParam( "tcoil" "tcoil_master" "schematic" "tcoil3_mmw" "nei" "5" )
lxGenFromSource( cv_schematic )
cv_layout = dbOpenCellViewByType("tcoil" "tcoil_master" "layout")
MovePinsToInstances( cv_schematic cv_layout )
StreamOutGDS("tcoil" "tcoil_master" "layout" "/autofs/fs1.ece/fs1.eecg.tcc/lizongh2/gf22x-1020b/EMX_work/tcoil_tcoil2868.work" "tcoil2868.gds")

cv_schematic = dbOpenCellViewByType("tcoil" "tcoil_master" "schematic")
CCSchangeParam( "tcoil" "tcoil_master" "schematic" "tcoil3_mmw" "pneo" "60" )
CCSchangeParam( "tcoil" "tcoil_master" "schematic" "tcoil3_mmw" "ctapLocation" "bot" )
CCSchangeParam( "tcoil" "tcoil_master" "schematic" "tcoil3_mmw" "od" "74u" )
CCSchangeParam( "tcoil" "tcoil_master" "schematic" "tcoil3_mmw" "w" "4.2u" )
CCSchangeParam( "tcoil" "tcoil_master" "schematic" "tcoil3_mmw" "neo" "12" )
CCSchangeParam( "tcoil" "tcoil_master" "schematic" "tcoil3_mmw" "nei" "5" )
lxGenFromSource( cv_schematic )
cv_layout = dbOpenCellViewByType("tcoil" "tcoil_master" "layout")
MovePinsToInstances( cv_schematic cv_layout )
StreamOutGDS("tcoil" "tcoil_master" "layout" "/autofs/fs1.ece/fs1.eecg.tcc/lizongh2/gf22x-1020b/EMX_work/tcoil_tcoil2869.work" "tcoil2869.gds")

cv_schematic = dbOpenCellViewByType("tcoil" "tcoil_master" "schematic")
CCSchangeParam( "tcoil" "tcoil_master" "schematic" "tcoil3_mmw" "pneo" "60" )
CCSchangeParam( "tcoil" "tcoil_master" "schematic" "tcoil3_mmw" "ctapLocation" "bot" )
CCSchangeParam( "tcoil" "tcoil_master" "schematic" "tcoil3_mmw" "od" "74u" )
CCSchangeParam( "tcoil" "tcoil_master" "schematic" "tcoil3_mmw" "w" "5.0u" )
CCSchangeParam( "tcoil" "tcoil_master" "schematic" "tcoil3_mmw" "neo" "4" )
CCSchangeParam( "tcoil" "tcoil_master" "schematic" "tcoil3_mmw" "nei" "5" )
lxGenFromSource( cv_schematic )
cv_layout = dbOpenCellViewByType("tcoil" "tcoil_master" "layout")
MovePinsToInstances( cv_schematic cv_layout )
StreamOutGDS("tcoil" "tcoil_master" "layout" "/autofs/fs1.ece/fs1.eecg.tcc/lizongh2/gf22x-1020b/EMX_work/tcoil_tcoil2870.work" "tcoil2870.gds")

cv_schematic = dbOpenCellViewByType("tcoil" "tcoil_master" "schematic")
CCSchangeParam( "tcoil" "tcoil_master" "schematic" "tcoil3_mmw" "pneo" "60" )
CCSchangeParam( "tcoil" "tcoil_master" "schematic" "tcoil3_mmw" "ctapLocation" "bot" )
CCSchangeParam( "tcoil" "tcoil_master" "schematic" "tcoil3_mmw" "od" "74u" )
CCSchangeParam( "tcoil" "tcoil_master" "schematic" "tcoil3_mmw" "w" "5.0u" )
CCSchangeParam( "tcoil" "tcoil_master" "schematic" "tcoil3_mmw" "neo" "6" )
CCSchangeParam( "tcoil" "tcoil_master" "schematic" "tcoil3_mmw" "nei" "5" )
lxGenFromSource( cv_schematic )
cv_layout = dbOpenCellViewByType("tcoil" "tcoil_master" "layout")
MovePinsToInstances( cv_schematic cv_layout )
StreamOutGDS("tcoil" "tcoil_master" "layout" "/autofs/fs1.ece/fs1.eecg.tcc/lizongh2/gf22x-1020b/EMX_work/tcoil_tcoil2871.work" "tcoil2871.gds")

cv_schematic = dbOpenCellViewByType("tcoil" "tcoil_master" "schematic")
CCSchangeParam( "tcoil" "tcoil_master" "schematic" "tcoil3_mmw" "pneo" "60" )
CCSchangeParam( "tcoil" "tcoil_master" "schematic" "tcoil3_mmw" "ctapLocation" "bot" )
CCSchangeParam( "tcoil" "tcoil_master" "schematic" "tcoil3_mmw" "od" "74u" )
CCSchangeParam( "tcoil" "tcoil_master" "schematic" "tcoil3_mmw" "w" "5.0u" )
CCSchangeParam( "tcoil" "tcoil_master" "schematic" "tcoil3_mmw" "neo" "8" )
CCSchangeParam( "tcoil" "tcoil_master" "schematic" "tcoil3_mmw" "nei" "5" )
lxGenFromSource( cv_schematic )
cv_layout = dbOpenCellViewByType("tcoil" "tcoil_master" "layout")
MovePinsToInstances( cv_schematic cv_layout )
StreamOutGDS("tcoil" "tcoil_master" "layout" "/autofs/fs1.ece/fs1.eecg.tcc/lizongh2/gf22x-1020b/EMX_work/tcoil_tcoil2872.work" "tcoil2872.gds")

cv_schematic = dbOpenCellViewByType("tcoil" "tcoil_master" "schematic")
CCSchangeParam( "tcoil" "tcoil_master" "schematic" "tcoil3_mmw" "pneo" "60" )
CCSchangeParam( "tcoil" "tcoil_master" "schematic" "tcoil3_mmw" "ctapLocation" "bot" )
CCSchangeParam( "tcoil" "tcoil_master" "schematic" "tcoil3_mmw" "od" "74u" )
CCSchangeParam( "tcoil" "tcoil_master" "schematic" "tcoil3_mmw" "w" "5.0u" )
CCSchangeParam( "tcoil" "tcoil_master" "schematic" "tcoil3_mmw" "neo" "10" )
CCSchangeParam( "tcoil" "tcoil_master" "schematic" "tcoil3_mmw" "nei" "5" )
lxGenFromSource( cv_schematic )
cv_layout = dbOpenCellViewByType("tcoil" "tcoil_master" "layout")
MovePinsToInstances( cv_schematic cv_layout )
StreamOutGDS("tcoil" "tcoil_master" "layout" "/autofs/fs1.ece/fs1.eecg.tcc/lizongh2/gf22x-1020b/EMX_work/tcoil_tcoil2873.work" "tcoil2873.gds")

cv_schematic = dbOpenCellViewByType("tcoil" "tcoil_master" "schematic")
CCSchangeParam( "tcoil" "tcoil_master" "schematic" "tcoil3_mmw" "pneo" "60" )
CCSchangeParam( "tcoil" "tcoil_master" "schematic" "tcoil3_mmw" "ctapLocation" "bot" )
CCSchangeParam( "tcoil" "tcoil_master" "schematic" "tcoil3_mmw" "od" "74u" )
CCSchangeParam( "tcoil" "tcoil_master" "schematic" "tcoil3_mmw" "w" "5.0u" )
CCSchangeParam( "tcoil" "tcoil_master" "schematic" "tcoil3_mmw" "neo" "12" )
CCSchangeParam( "tcoil" "tcoil_master" "schematic" "tcoil3_mmw" "nei" "5" )
lxGenFromSource( cv_schematic )
cv_layout = dbOpenCellViewByType("tcoil" "tcoil_master" "layout")
MovePinsToInstances( cv_schematic cv_layout )
StreamOutGDS("tcoil" "tcoil_master" "layout" "/autofs/fs1.ece/fs1.eecg.tcc/lizongh2/gf22x-1020b/EMX_work/tcoil_tcoil2874.work" "tcoil2874.gds")

cv_schematic = dbOpenCellViewByType("tcoil" "tcoil_master" "schematic")
CCSchangeParam( "tcoil" "tcoil_master" "schematic" "tcoil3_mmw" "pneo" "60" )
CCSchangeParam( "tcoil" "tcoil_master" "schematic" "tcoil3_mmw" "ctapLocation" "bot" )
CCSchangeParam( "tcoil" "tcoil_master" "schematic" "tcoil3_mmw" "od" "76u" )
CCSchangeParam( "tcoil" "tcoil_master" "schematic" "tcoil3_mmw" "w" "2.4u" )
CCSchangeParam( "tcoil" "tcoil_master" "schematic" "tcoil3_mmw" "neo" "4" )
CCSchangeParam( "tcoil" "tcoil_master" "schematic" "tcoil3_mmw" "nei" "5" )
lxGenFromSource( cv_schematic )
cv_layout = dbOpenCellViewByType("tcoil" "tcoil_master" "layout")
MovePinsToInstances( cv_schematic cv_layout )
StreamOutGDS("tcoil" "tcoil_master" "layout" "/autofs/fs1.ece/fs1.eecg.tcc/lizongh2/gf22x-1020b/EMX_work/tcoil_tcoil2875.work" "tcoil2875.gds")

cv_schematic = dbOpenCellViewByType("tcoil" "tcoil_master" "schematic")
CCSchangeParam( "tcoil" "tcoil_master" "schematic" "tcoil3_mmw" "pneo" "60" )
CCSchangeParam( "tcoil" "tcoil_master" "schematic" "tcoil3_mmw" "ctapLocation" "bot" )
CCSchangeParam( "tcoil" "tcoil_master" "schematic" "tcoil3_mmw" "od" "76u" )
CCSchangeParam( "tcoil" "tcoil_master" "schematic" "tcoil3_mmw" "w" "2.4u" )
CCSchangeParam( "tcoil" "tcoil_master" "schematic" "tcoil3_mmw" "neo" "6" )
CCSchangeParam( "tcoil" "tcoil_master" "schematic" "tcoil3_mmw" "nei" "5" )
lxGenFromSource( cv_schematic )
cv_layout = dbOpenCellViewByType("tcoil" "tcoil_master" "layout")
MovePinsToInstances( cv_schematic cv_layout )
StreamOutGDS("tcoil" "tcoil_master" "layout" "/autofs/fs1.ece/fs1.eecg.tcc/lizongh2/gf22x-1020b/EMX_work/tcoil_tcoil2876.work" "tcoil2876.gds")

cv_schematic = dbOpenCellViewByType("tcoil" "tcoil_master" "schematic")
CCSchangeParam( "tcoil" "tcoil_master" "schematic" "tcoil3_mmw" "pneo" "60" )
CCSchangeParam( "tcoil" "tcoil_master" "schematic" "tcoil3_mmw" "ctapLocation" "bot" )
CCSchangeParam( "tcoil" "tcoil_master" "schematic" "tcoil3_mmw" "od" "76u" )
CCSchangeParam( "tcoil" "tcoil_master" "schematic" "tcoil3_mmw" "w" "2.4u" )
CCSchangeParam( "tcoil" "tcoil_master" "schematic" "tcoil3_mmw" "neo" "8" )
CCSchangeParam( "tcoil" "tcoil_master" "schematic" "tcoil3_mmw" "nei" "5" )
lxGenFromSource( cv_schematic )
cv_layout = dbOpenCellViewByType("tcoil" "tcoil_master" "layout")
MovePinsToInstances( cv_schematic cv_layout )
StreamOutGDS("tcoil" "tcoil_master" "layout" "/autofs/fs1.ece/fs1.eecg.tcc/lizongh2/gf22x-1020b/EMX_work/tcoil_tcoil2877.work" "tcoil2877.gds")

cv_schematic = dbOpenCellViewByType("tcoil" "tcoil_master" "schematic")
CCSchangeParam( "tcoil" "tcoil_master" "schematic" "tcoil3_mmw" "pneo" "60" )
CCSchangeParam( "tcoil" "tcoil_master" "schematic" "tcoil3_mmw" "ctapLocation" "bot" )
CCSchangeParam( "tcoil" "tcoil_master" "schematic" "tcoil3_mmw" "od" "76u" )
CCSchangeParam( "tcoil" "tcoil_master" "schematic" "tcoil3_mmw" "w" "2.4u" )
CCSchangeParam( "tcoil" "tcoil_master" "schematic" "tcoil3_mmw" "neo" "10" )
CCSchangeParam( "tcoil" "tcoil_master" "schematic" "tcoil3_mmw" "nei" "5" )
lxGenFromSource( cv_schematic )
cv_layout = dbOpenCellViewByType("tcoil" "tcoil_master" "layout")
MovePinsToInstances( cv_schematic cv_layout )
StreamOutGDS("tcoil" "tcoil_master" "layout" "/autofs/fs1.ece/fs1.eecg.tcc/lizongh2/gf22x-1020b/EMX_work/tcoil_tcoil2878.work" "tcoil2878.gds")

cv_schematic = dbOpenCellViewByType("tcoil" "tcoil_master" "schematic")
CCSchangeParam( "tcoil" "tcoil_master" "schematic" "tcoil3_mmw" "pneo" "60" )
CCSchangeParam( "tcoil" "tcoil_master" "schematic" "tcoil3_mmw" "ctapLocation" "bot" )
CCSchangeParam( "tcoil" "tcoil_master" "schematic" "tcoil3_mmw" "od" "76u" )
CCSchangeParam( "tcoil" "tcoil_master" "schematic" "tcoil3_mmw" "w" "2.4u" )
CCSchangeParam( "tcoil" "tcoil_master" "schematic" "tcoil3_mmw" "neo" "12" )
CCSchangeParam( "tcoil" "tcoil_master" "schematic" "tcoil3_mmw" "nei" "5" )
lxGenFromSource( cv_schematic )
cv_layout = dbOpenCellViewByType("tcoil" "tcoil_master" "layout")
MovePinsToInstances( cv_schematic cv_layout )
StreamOutGDS("tcoil" "tcoil_master" "layout" "/autofs/fs1.ece/fs1.eecg.tcc/lizongh2/gf22x-1020b/EMX_work/tcoil_tcoil2879.work" "tcoil2879.gds")

cv_schematic = dbOpenCellViewByType("tcoil" "tcoil_master" "schematic")
CCSchangeParam( "tcoil" "tcoil_master" "schematic" "tcoil3_mmw" "pneo" "60" )
CCSchangeParam( "tcoil" "tcoil_master" "schematic" "tcoil3_mmw" "ctapLocation" "bot" )
CCSchangeParam( "tcoil" "tcoil_master" "schematic" "tcoil3_mmw" "od" "76u" )
CCSchangeParam( "tcoil" "tcoil_master" "schematic" "tcoil3_mmw" "w" "4.2u" )
CCSchangeParam( "tcoil" "tcoil_master" "schematic" "tcoil3_mmw" "neo" "4" )
CCSchangeParam( "tcoil" "tcoil_master" "schematic" "tcoil3_mmw" "nei" "5" )
lxGenFromSource( cv_schematic )
cv_layout = dbOpenCellViewByType("tcoil" "tcoil_master" "layout")
MovePinsToInstances( cv_schematic cv_layout )
StreamOutGDS("tcoil" "tcoil_master" "layout" "/autofs/fs1.ece/fs1.eecg.tcc/lizongh2/gf22x-1020b/EMX_work/tcoil_tcoil2880.work" "tcoil2880.gds")

cv_schematic = dbOpenCellViewByType("tcoil" "tcoil_master" "schematic")
CCSchangeParam( "tcoil" "tcoil_master" "schematic" "tcoil3_mmw" "pneo" "60" )
CCSchangeParam( "tcoil" "tcoil_master" "schematic" "tcoil3_mmw" "ctapLocation" "bot" )
CCSchangeParam( "tcoil" "tcoil_master" "schematic" "tcoil3_mmw" "od" "76u" )
CCSchangeParam( "tcoil" "tcoil_master" "schematic" "tcoil3_mmw" "w" "4.2u" )
CCSchangeParam( "tcoil" "tcoil_master" "schematic" "tcoil3_mmw" "neo" "6" )
CCSchangeParam( "tcoil" "tcoil_master" "schematic" "tcoil3_mmw" "nei" "5" )
lxGenFromSource( cv_schematic )
cv_layout = dbOpenCellViewByType("tcoil" "tcoil_master" "layout")
MovePinsToInstances( cv_schematic cv_layout )
StreamOutGDS("tcoil" "tcoil_master" "layout" "/autofs/fs1.ece/fs1.eecg.tcc/lizongh2/gf22x-1020b/EMX_work/tcoil_tcoil2881.work" "tcoil2881.gds")

cv_schematic = dbOpenCellViewByType("tcoil" "tcoil_master" "schematic")
CCSchangeParam( "tcoil" "tcoil_master" "schematic" "tcoil3_mmw" "pneo" "60" )
CCSchangeParam( "tcoil" "tcoil_master" "schematic" "tcoil3_mmw" "ctapLocation" "bot" )
CCSchangeParam( "tcoil" "tcoil_master" "schematic" "tcoil3_mmw" "od" "76u" )
CCSchangeParam( "tcoil" "tcoil_master" "schematic" "tcoil3_mmw" "w" "4.2u" )
CCSchangeParam( "tcoil" "tcoil_master" "schematic" "tcoil3_mmw" "neo" "8" )
CCSchangeParam( "tcoil" "tcoil_master" "schematic" "tcoil3_mmw" "nei" "5" )
lxGenFromSource( cv_schematic )
cv_layout = dbOpenCellViewByType("tcoil" "tcoil_master" "layout")
MovePinsToInstances( cv_schematic cv_layout )
StreamOutGDS("tcoil" "tcoil_master" "layout" "/autofs/fs1.ece/fs1.eecg.tcc/lizongh2/gf22x-1020b/EMX_work/tcoil_tcoil2882.work" "tcoil2882.gds")

cv_schematic = dbOpenCellViewByType("tcoil" "tcoil_master" "schematic")
CCSchangeParam( "tcoil" "tcoil_master" "schematic" "tcoil3_mmw" "pneo" "60" )
CCSchangeParam( "tcoil" "tcoil_master" "schematic" "tcoil3_mmw" "ctapLocation" "bot" )
CCSchangeParam( "tcoil" "tcoil_master" "schematic" "tcoil3_mmw" "od" "76u" )
CCSchangeParam( "tcoil" "tcoil_master" "schematic" "tcoil3_mmw" "w" "4.2u" )
CCSchangeParam( "tcoil" "tcoil_master" "schematic" "tcoil3_mmw" "neo" "10" )
CCSchangeParam( "tcoil" "tcoil_master" "schematic" "tcoil3_mmw" "nei" "5" )
lxGenFromSource( cv_schematic )
cv_layout = dbOpenCellViewByType("tcoil" "tcoil_master" "layout")
MovePinsToInstances( cv_schematic cv_layout )
StreamOutGDS("tcoil" "tcoil_master" "layout" "/autofs/fs1.ece/fs1.eecg.tcc/lizongh2/gf22x-1020b/EMX_work/tcoil_tcoil2883.work" "tcoil2883.gds")

cv_schematic = dbOpenCellViewByType("tcoil" "tcoil_master" "schematic")
CCSchangeParam( "tcoil" "tcoil_master" "schematic" "tcoil3_mmw" "pneo" "60" )
CCSchangeParam( "tcoil" "tcoil_master" "schematic" "tcoil3_mmw" "ctapLocation" "bot" )
CCSchangeParam( "tcoil" "tcoil_master" "schematic" "tcoil3_mmw" "od" "76u" )
CCSchangeParam( "tcoil" "tcoil_master" "schematic" "tcoil3_mmw" "w" "4.2u" )
CCSchangeParam( "tcoil" "tcoil_master" "schematic" "tcoil3_mmw" "neo" "12" )
CCSchangeParam( "tcoil" "tcoil_master" "schematic" "tcoil3_mmw" "nei" "5" )
lxGenFromSource( cv_schematic )
cv_layout = dbOpenCellViewByType("tcoil" "tcoil_master" "layout")
MovePinsToInstances( cv_schematic cv_layout )
StreamOutGDS("tcoil" "tcoil_master" "layout" "/autofs/fs1.ece/fs1.eecg.tcc/lizongh2/gf22x-1020b/EMX_work/tcoil_tcoil2884.work" "tcoil2884.gds")

cv_schematic = dbOpenCellViewByType("tcoil" "tcoil_master" "schematic")
CCSchangeParam( "tcoil" "tcoil_master" "schematic" "tcoil3_mmw" "pneo" "60" )
CCSchangeParam( "tcoil" "tcoil_master" "schematic" "tcoil3_mmw" "ctapLocation" "bot" )
CCSchangeParam( "tcoil" "tcoil_master" "schematic" "tcoil3_mmw" "od" "76u" )
CCSchangeParam( "tcoil" "tcoil_master" "schematic" "tcoil3_mmw" "w" "5.0u" )
CCSchangeParam( "tcoil" "tcoil_master" "schematic" "tcoil3_mmw" "neo" "4" )
CCSchangeParam( "tcoil" "tcoil_master" "schematic" "tcoil3_mmw" "nei" "5" )
lxGenFromSource( cv_schematic )
cv_layout = dbOpenCellViewByType("tcoil" "tcoil_master" "layout")
MovePinsToInstances( cv_schematic cv_layout )
StreamOutGDS("tcoil" "tcoil_master" "layout" "/autofs/fs1.ece/fs1.eecg.tcc/lizongh2/gf22x-1020b/EMX_work/tcoil_tcoil2885.work" "tcoil2885.gds")

cv_schematic = dbOpenCellViewByType("tcoil" "tcoil_master" "schematic")
CCSchangeParam( "tcoil" "tcoil_master" "schematic" "tcoil3_mmw" "pneo" "60" )
CCSchangeParam( "tcoil" "tcoil_master" "schematic" "tcoil3_mmw" "ctapLocation" "bot" )
CCSchangeParam( "tcoil" "tcoil_master" "schematic" "tcoil3_mmw" "od" "76u" )
CCSchangeParam( "tcoil" "tcoil_master" "schematic" "tcoil3_mmw" "w" "5.0u" )
CCSchangeParam( "tcoil" "tcoil_master" "schematic" "tcoil3_mmw" "neo" "6" )
CCSchangeParam( "tcoil" "tcoil_master" "schematic" "tcoil3_mmw" "nei" "5" )
lxGenFromSource( cv_schematic )
cv_layout = dbOpenCellViewByType("tcoil" "tcoil_master" "layout")
MovePinsToInstances( cv_schematic cv_layout )
StreamOutGDS("tcoil" "tcoil_master" "layout" "/autofs/fs1.ece/fs1.eecg.tcc/lizongh2/gf22x-1020b/EMX_work/tcoil_tcoil2886.work" "tcoil2886.gds")

cv_schematic = dbOpenCellViewByType("tcoil" "tcoil_master" "schematic")
CCSchangeParam( "tcoil" "tcoil_master" "schematic" "tcoil3_mmw" "pneo" "60" )
CCSchangeParam( "tcoil" "tcoil_master" "schematic" "tcoil3_mmw" "ctapLocation" "bot" )
CCSchangeParam( "tcoil" "tcoil_master" "schematic" "tcoil3_mmw" "od" "76u" )
CCSchangeParam( "tcoil" "tcoil_master" "schematic" "tcoil3_mmw" "w" "5.0u" )
CCSchangeParam( "tcoil" "tcoil_master" "schematic" "tcoil3_mmw" "neo" "8" )
CCSchangeParam( "tcoil" "tcoil_master" "schematic" "tcoil3_mmw" "nei" "5" )
lxGenFromSource( cv_schematic )
cv_layout = dbOpenCellViewByType("tcoil" "tcoil_master" "layout")
MovePinsToInstances( cv_schematic cv_layout )
StreamOutGDS("tcoil" "tcoil_master" "layout" "/autofs/fs1.ece/fs1.eecg.tcc/lizongh2/gf22x-1020b/EMX_work/tcoil_tcoil2887.work" "tcoil2887.gds")

cv_schematic = dbOpenCellViewByType("tcoil" "tcoil_master" "schematic")
CCSchangeParam( "tcoil" "tcoil_master" "schematic" "tcoil3_mmw" "pneo" "60" )
CCSchangeParam( "tcoil" "tcoil_master" "schematic" "tcoil3_mmw" "ctapLocation" "bot" )
CCSchangeParam( "tcoil" "tcoil_master" "schematic" "tcoil3_mmw" "od" "76u" )
CCSchangeParam( "tcoil" "tcoil_master" "schematic" "tcoil3_mmw" "w" "5.0u" )
CCSchangeParam( "tcoil" "tcoil_master" "schematic" "tcoil3_mmw" "neo" "10" )
CCSchangeParam( "tcoil" "tcoil_master" "schematic" "tcoil3_mmw" "nei" "5" )
lxGenFromSource( cv_schematic )
cv_layout = dbOpenCellViewByType("tcoil" "tcoil_master" "layout")
MovePinsToInstances( cv_schematic cv_layout )
StreamOutGDS("tcoil" "tcoil_master" "layout" "/autofs/fs1.ece/fs1.eecg.tcc/lizongh2/gf22x-1020b/EMX_work/tcoil_tcoil2888.work" "tcoil2888.gds")

cv_schematic = dbOpenCellViewByType("tcoil" "tcoil_master" "schematic")
CCSchangeParam( "tcoil" "tcoil_master" "schematic" "tcoil3_mmw" "pneo" "60" )
CCSchangeParam( "tcoil" "tcoil_master" "schematic" "tcoil3_mmw" "ctapLocation" "bot" )
CCSchangeParam( "tcoil" "tcoil_master" "schematic" "tcoil3_mmw" "od" "76u" )
CCSchangeParam( "tcoil" "tcoil_master" "schematic" "tcoil3_mmw" "w" "5.0u" )
CCSchangeParam( "tcoil" "tcoil_master" "schematic" "tcoil3_mmw" "neo" "12" )
CCSchangeParam( "tcoil" "tcoil_master" "schematic" "tcoil3_mmw" "nei" "5" )
lxGenFromSource( cv_schematic )
cv_layout = dbOpenCellViewByType("tcoil" "tcoil_master" "layout")
MovePinsToInstances( cv_schematic cv_layout )
StreamOutGDS("tcoil" "tcoil_master" "layout" "/autofs/fs1.ece/fs1.eecg.tcc/lizongh2/gf22x-1020b/EMX_work/tcoil_tcoil2889.work" "tcoil2889.gds")

cv_schematic = dbOpenCellViewByType("tcoil" "tcoil_master" "schematic")
CCSchangeParam( "tcoil" "tcoil_master" "schematic" "tcoil3_mmw" "pneo" "60" )
CCSchangeParam( "tcoil" "tcoil_master" "schematic" "tcoil3_mmw" "ctapLocation" "bot" )
CCSchangeParam( "tcoil" "tcoil_master" "schematic" "tcoil3_mmw" "od" "78u" )
CCSchangeParam( "tcoil" "tcoil_master" "schematic" "tcoil3_mmw" "w" "2.4u" )
CCSchangeParam( "tcoil" "tcoil_master" "schematic" "tcoil3_mmw" "neo" "4" )
CCSchangeParam( "tcoil" "tcoil_master" "schematic" "tcoil3_mmw" "nei" "5" )
lxGenFromSource( cv_schematic )
cv_layout = dbOpenCellViewByType("tcoil" "tcoil_master" "layout")
MovePinsToInstances( cv_schematic cv_layout )
StreamOutGDS("tcoil" "tcoil_master" "layout" "/autofs/fs1.ece/fs1.eecg.tcc/lizongh2/gf22x-1020b/EMX_work/tcoil_tcoil2890.work" "tcoil2890.gds")

cv_schematic = dbOpenCellViewByType("tcoil" "tcoil_master" "schematic")
CCSchangeParam( "tcoil" "tcoil_master" "schematic" "tcoil3_mmw" "pneo" "60" )
CCSchangeParam( "tcoil" "tcoil_master" "schematic" "tcoil3_mmw" "ctapLocation" "bot" )
CCSchangeParam( "tcoil" "tcoil_master" "schematic" "tcoil3_mmw" "od" "78u" )
CCSchangeParam( "tcoil" "tcoil_master" "schematic" "tcoil3_mmw" "w" "2.4u" )
CCSchangeParam( "tcoil" "tcoil_master" "schematic" "tcoil3_mmw" "neo" "6" )
CCSchangeParam( "tcoil" "tcoil_master" "schematic" "tcoil3_mmw" "nei" "5" )
lxGenFromSource( cv_schematic )
cv_layout = dbOpenCellViewByType("tcoil" "tcoil_master" "layout")
MovePinsToInstances( cv_schematic cv_layout )
StreamOutGDS("tcoil" "tcoil_master" "layout" "/autofs/fs1.ece/fs1.eecg.tcc/lizongh2/gf22x-1020b/EMX_work/tcoil_tcoil2891.work" "tcoil2891.gds")

cv_schematic = dbOpenCellViewByType("tcoil" "tcoil_master" "schematic")
CCSchangeParam( "tcoil" "tcoil_master" "schematic" "tcoil3_mmw" "pneo" "60" )
CCSchangeParam( "tcoil" "tcoil_master" "schematic" "tcoil3_mmw" "ctapLocation" "bot" )
CCSchangeParam( "tcoil" "tcoil_master" "schematic" "tcoil3_mmw" "od" "78u" )
CCSchangeParam( "tcoil" "tcoil_master" "schematic" "tcoil3_mmw" "w" "2.4u" )
CCSchangeParam( "tcoil" "tcoil_master" "schematic" "tcoil3_mmw" "neo" "8" )
CCSchangeParam( "tcoil" "tcoil_master" "schematic" "tcoil3_mmw" "nei" "5" )
lxGenFromSource( cv_schematic )
cv_layout = dbOpenCellViewByType("tcoil" "tcoil_master" "layout")
MovePinsToInstances( cv_schematic cv_layout )
StreamOutGDS("tcoil" "tcoil_master" "layout" "/autofs/fs1.ece/fs1.eecg.tcc/lizongh2/gf22x-1020b/EMX_work/tcoil_tcoil2892.work" "tcoil2892.gds")

cv_schematic = dbOpenCellViewByType("tcoil" "tcoil_master" "schematic")
CCSchangeParam( "tcoil" "tcoil_master" "schematic" "tcoil3_mmw" "pneo" "60" )
CCSchangeParam( "tcoil" "tcoil_master" "schematic" "tcoil3_mmw" "ctapLocation" "bot" )
CCSchangeParam( "tcoil" "tcoil_master" "schematic" "tcoil3_mmw" "od" "78u" )
CCSchangeParam( "tcoil" "tcoil_master" "schematic" "tcoil3_mmw" "w" "2.4u" )
CCSchangeParam( "tcoil" "tcoil_master" "schematic" "tcoil3_mmw" "neo" "10" )
CCSchangeParam( "tcoil" "tcoil_master" "schematic" "tcoil3_mmw" "nei" "5" )
lxGenFromSource( cv_schematic )
cv_layout = dbOpenCellViewByType("tcoil" "tcoil_master" "layout")
MovePinsToInstances( cv_schematic cv_layout )
StreamOutGDS("tcoil" "tcoil_master" "layout" "/autofs/fs1.ece/fs1.eecg.tcc/lizongh2/gf22x-1020b/EMX_work/tcoil_tcoil2893.work" "tcoil2893.gds")

cv_schematic = dbOpenCellViewByType("tcoil" "tcoil_master" "schematic")
CCSchangeParam( "tcoil" "tcoil_master" "schematic" "tcoil3_mmw" "pneo" "60" )
CCSchangeParam( "tcoil" "tcoil_master" "schematic" "tcoil3_mmw" "ctapLocation" "bot" )
CCSchangeParam( "tcoil" "tcoil_master" "schematic" "tcoil3_mmw" "od" "78u" )
CCSchangeParam( "tcoil" "tcoil_master" "schematic" "tcoil3_mmw" "w" "2.4u" )
CCSchangeParam( "tcoil" "tcoil_master" "schematic" "tcoil3_mmw" "neo" "12" )
CCSchangeParam( "tcoil" "tcoil_master" "schematic" "tcoil3_mmw" "nei" "5" )
lxGenFromSource( cv_schematic )
cv_layout = dbOpenCellViewByType("tcoil" "tcoil_master" "layout")
MovePinsToInstances( cv_schematic cv_layout )
StreamOutGDS("tcoil" "tcoil_master" "layout" "/autofs/fs1.ece/fs1.eecg.tcc/lizongh2/gf22x-1020b/EMX_work/tcoil_tcoil2894.work" "tcoil2894.gds")

cv_schematic = dbOpenCellViewByType("tcoil" "tcoil_master" "schematic")
CCSchangeParam( "tcoil" "tcoil_master" "schematic" "tcoil3_mmw" "pneo" "60" )
CCSchangeParam( "tcoil" "tcoil_master" "schematic" "tcoil3_mmw" "ctapLocation" "bot" )
CCSchangeParam( "tcoil" "tcoil_master" "schematic" "tcoil3_mmw" "od" "78u" )
CCSchangeParam( "tcoil" "tcoil_master" "schematic" "tcoil3_mmw" "w" "4.2u" )
CCSchangeParam( "tcoil" "tcoil_master" "schematic" "tcoil3_mmw" "neo" "4" )
CCSchangeParam( "tcoil" "tcoil_master" "schematic" "tcoil3_mmw" "nei" "5" )
lxGenFromSource( cv_schematic )
cv_layout = dbOpenCellViewByType("tcoil" "tcoil_master" "layout")
MovePinsToInstances( cv_schematic cv_layout )
StreamOutGDS("tcoil" "tcoil_master" "layout" "/autofs/fs1.ece/fs1.eecg.tcc/lizongh2/gf22x-1020b/EMX_work/tcoil_tcoil2895.work" "tcoil2895.gds")

cv_schematic = dbOpenCellViewByType("tcoil" "tcoil_master" "schematic")
CCSchangeParam( "tcoil" "tcoil_master" "schematic" "tcoil3_mmw" "pneo" "60" )
CCSchangeParam( "tcoil" "tcoil_master" "schematic" "tcoil3_mmw" "ctapLocation" "bot" )
CCSchangeParam( "tcoil" "tcoil_master" "schematic" "tcoil3_mmw" "od" "78u" )
CCSchangeParam( "tcoil" "tcoil_master" "schematic" "tcoil3_mmw" "w" "4.2u" )
CCSchangeParam( "tcoil" "tcoil_master" "schematic" "tcoil3_mmw" "neo" "6" )
CCSchangeParam( "tcoil" "tcoil_master" "schematic" "tcoil3_mmw" "nei" "5" )
lxGenFromSource( cv_schematic )
cv_layout = dbOpenCellViewByType("tcoil" "tcoil_master" "layout")
MovePinsToInstances( cv_schematic cv_layout )
StreamOutGDS("tcoil" "tcoil_master" "layout" "/autofs/fs1.ece/fs1.eecg.tcc/lizongh2/gf22x-1020b/EMX_work/tcoil_tcoil2896.work" "tcoil2896.gds")

cv_schematic = dbOpenCellViewByType("tcoil" "tcoil_master" "schematic")
CCSchangeParam( "tcoil" "tcoil_master" "schematic" "tcoil3_mmw" "pneo" "60" )
CCSchangeParam( "tcoil" "tcoil_master" "schematic" "tcoil3_mmw" "ctapLocation" "bot" )
CCSchangeParam( "tcoil" "tcoil_master" "schematic" "tcoil3_mmw" "od" "78u" )
CCSchangeParam( "tcoil" "tcoil_master" "schematic" "tcoil3_mmw" "w" "4.2u" )
CCSchangeParam( "tcoil" "tcoil_master" "schematic" "tcoil3_mmw" "neo" "8" )
CCSchangeParam( "tcoil" "tcoil_master" "schematic" "tcoil3_mmw" "nei" "5" )
lxGenFromSource( cv_schematic )
cv_layout = dbOpenCellViewByType("tcoil" "tcoil_master" "layout")
MovePinsToInstances( cv_schematic cv_layout )
StreamOutGDS("tcoil" "tcoil_master" "layout" "/autofs/fs1.ece/fs1.eecg.tcc/lizongh2/gf22x-1020b/EMX_work/tcoil_tcoil2897.work" "tcoil2897.gds")

cv_schematic = dbOpenCellViewByType("tcoil" "tcoil_master" "schematic")
CCSchangeParam( "tcoil" "tcoil_master" "schematic" "tcoil3_mmw" "pneo" "60" )
CCSchangeParam( "tcoil" "tcoil_master" "schematic" "tcoil3_mmw" "ctapLocation" "bot" )
CCSchangeParam( "tcoil" "tcoil_master" "schematic" "tcoil3_mmw" "od" "78u" )
CCSchangeParam( "tcoil" "tcoil_master" "schematic" "tcoil3_mmw" "w" "4.2u" )
CCSchangeParam( "tcoil" "tcoil_master" "schematic" "tcoil3_mmw" "neo" "10" )
CCSchangeParam( "tcoil" "tcoil_master" "schematic" "tcoil3_mmw" "nei" "5" )
lxGenFromSource( cv_schematic )
cv_layout = dbOpenCellViewByType("tcoil" "tcoil_master" "layout")
MovePinsToInstances( cv_schematic cv_layout )
StreamOutGDS("tcoil" "tcoil_master" "layout" "/autofs/fs1.ece/fs1.eecg.tcc/lizongh2/gf22x-1020b/EMX_work/tcoil_tcoil2898.work" "tcoil2898.gds")

cv_schematic = dbOpenCellViewByType("tcoil" "tcoil_master" "schematic")
CCSchangeParam( "tcoil" "tcoil_master" "schematic" "tcoil3_mmw" "pneo" "60" )
CCSchangeParam( "tcoil" "tcoil_master" "schematic" "tcoil3_mmw" "ctapLocation" "bot" )
CCSchangeParam( "tcoil" "tcoil_master" "schematic" "tcoil3_mmw" "od" "78u" )
CCSchangeParam( "tcoil" "tcoil_master" "schematic" "tcoil3_mmw" "w" "4.2u" )
CCSchangeParam( "tcoil" "tcoil_master" "schematic" "tcoil3_mmw" "neo" "12" )
CCSchangeParam( "tcoil" "tcoil_master" "schematic" "tcoil3_mmw" "nei" "5" )
lxGenFromSource( cv_schematic )
cv_layout = dbOpenCellViewByType("tcoil" "tcoil_master" "layout")
MovePinsToInstances( cv_schematic cv_layout )
StreamOutGDS("tcoil" "tcoil_master" "layout" "/autofs/fs1.ece/fs1.eecg.tcc/lizongh2/gf22x-1020b/EMX_work/tcoil_tcoil2899.work" "tcoil2899.gds")

cv_schematic = dbOpenCellViewByType("tcoil" "tcoil_master" "schematic")
CCSchangeParam( "tcoil" "tcoil_master" "schematic" "tcoil3_mmw" "pneo" "60" )
CCSchangeParam( "tcoil" "tcoil_master" "schematic" "tcoil3_mmw" "ctapLocation" "bot" )
CCSchangeParam( "tcoil" "tcoil_master" "schematic" "tcoil3_mmw" "od" "78u" )
CCSchangeParam( "tcoil" "tcoil_master" "schematic" "tcoil3_mmw" "w" "5.0u" )
CCSchangeParam( "tcoil" "tcoil_master" "schematic" "tcoil3_mmw" "neo" "4" )
CCSchangeParam( "tcoil" "tcoil_master" "schematic" "tcoil3_mmw" "nei" "5" )
lxGenFromSource( cv_schematic )
cv_layout = dbOpenCellViewByType("tcoil" "tcoil_master" "layout")
MovePinsToInstances( cv_schematic cv_layout )
StreamOutGDS("tcoil" "tcoil_master" "layout" "/autofs/fs1.ece/fs1.eecg.tcc/lizongh2/gf22x-1020b/EMX_work/tcoil_tcoil2900.work" "tcoil2900.gds")

cv_schematic = dbOpenCellViewByType("tcoil" "tcoil_master" "schematic")
CCSchangeParam( "tcoil" "tcoil_master" "schematic" "tcoil3_mmw" "pneo" "60" )
CCSchangeParam( "tcoil" "tcoil_master" "schematic" "tcoil3_mmw" "ctapLocation" "bot" )
CCSchangeParam( "tcoil" "tcoil_master" "schematic" "tcoil3_mmw" "od" "78u" )
CCSchangeParam( "tcoil" "tcoil_master" "schematic" "tcoil3_mmw" "w" "5.0u" )
CCSchangeParam( "tcoil" "tcoil_master" "schematic" "tcoil3_mmw" "neo" "6" )
CCSchangeParam( "tcoil" "tcoil_master" "schematic" "tcoil3_mmw" "nei" "5" )
lxGenFromSource( cv_schematic )
cv_layout = dbOpenCellViewByType("tcoil" "tcoil_master" "layout")
MovePinsToInstances( cv_schematic cv_layout )
StreamOutGDS("tcoil" "tcoil_master" "layout" "/autofs/fs1.ece/fs1.eecg.tcc/lizongh2/gf22x-1020b/EMX_work/tcoil_tcoil2901.work" "tcoil2901.gds")

cv_schematic = dbOpenCellViewByType("tcoil" "tcoil_master" "schematic")
CCSchangeParam( "tcoil" "tcoil_master" "schematic" "tcoil3_mmw" "pneo" "60" )
CCSchangeParam( "tcoil" "tcoil_master" "schematic" "tcoil3_mmw" "ctapLocation" "bot" )
CCSchangeParam( "tcoil" "tcoil_master" "schematic" "tcoil3_mmw" "od" "78u" )
CCSchangeParam( "tcoil" "tcoil_master" "schematic" "tcoil3_mmw" "w" "5.0u" )
CCSchangeParam( "tcoil" "tcoil_master" "schematic" "tcoil3_mmw" "neo" "8" )
CCSchangeParam( "tcoil" "tcoil_master" "schematic" "tcoil3_mmw" "nei" "5" )
lxGenFromSource( cv_schematic )
cv_layout = dbOpenCellViewByType("tcoil" "tcoil_master" "layout")
MovePinsToInstances( cv_schematic cv_layout )
StreamOutGDS("tcoil" "tcoil_master" "layout" "/autofs/fs1.ece/fs1.eecg.tcc/lizongh2/gf22x-1020b/EMX_work/tcoil_tcoil2902.work" "tcoil2902.gds")

cv_schematic = dbOpenCellViewByType("tcoil" "tcoil_master" "schematic")
CCSchangeParam( "tcoil" "tcoil_master" "schematic" "tcoil3_mmw" "pneo" "60" )
CCSchangeParam( "tcoil" "tcoil_master" "schematic" "tcoil3_mmw" "ctapLocation" "bot" )
CCSchangeParam( "tcoil" "tcoil_master" "schematic" "tcoil3_mmw" "od" "78u" )
CCSchangeParam( "tcoil" "tcoil_master" "schematic" "tcoil3_mmw" "w" "5.0u" )
CCSchangeParam( "tcoil" "tcoil_master" "schematic" "tcoil3_mmw" "neo" "10" )
CCSchangeParam( "tcoil" "tcoil_master" "schematic" "tcoil3_mmw" "nei" "5" )
lxGenFromSource( cv_schematic )
cv_layout = dbOpenCellViewByType("tcoil" "tcoil_master" "layout")
MovePinsToInstances( cv_schematic cv_layout )
StreamOutGDS("tcoil" "tcoil_master" "layout" "/autofs/fs1.ece/fs1.eecg.tcc/lizongh2/gf22x-1020b/EMX_work/tcoil_tcoil2903.work" "tcoil2903.gds")

cv_schematic = dbOpenCellViewByType("tcoil" "tcoil_master" "schematic")
CCSchangeParam( "tcoil" "tcoil_master" "schematic" "tcoil3_mmw" "pneo" "60" )
CCSchangeParam( "tcoil" "tcoil_master" "schematic" "tcoil3_mmw" "ctapLocation" "bot" )
CCSchangeParam( "tcoil" "tcoil_master" "schematic" "tcoil3_mmw" "od" "78u" )
CCSchangeParam( "tcoil" "tcoil_master" "schematic" "tcoil3_mmw" "w" "5.0u" )
CCSchangeParam( "tcoil" "tcoil_master" "schematic" "tcoil3_mmw" "neo" "12" )
CCSchangeParam( "tcoil" "tcoil_master" "schematic" "tcoil3_mmw" "nei" "5" )
lxGenFromSource( cv_schematic )
cv_layout = dbOpenCellViewByType("tcoil" "tcoil_master" "layout")
MovePinsToInstances( cv_schematic cv_layout )
StreamOutGDS("tcoil" "tcoil_master" "layout" "/autofs/fs1.ece/fs1.eecg.tcc/lizongh2/gf22x-1020b/EMX_work/tcoil_tcoil2904.work" "tcoil2904.gds")

cv_schematic = dbOpenCellViewByType("tcoil" "tcoil_master" "schematic")
CCSchangeParam( "tcoil" "tcoil_master" "schematic" "tcoil3_mmw" "pneo" "60" )
CCSchangeParam( "tcoil" "tcoil_master" "schematic" "tcoil3_mmw" "ctapLocation" "bot" )
CCSchangeParam( "tcoil" "tcoil_master" "schematic" "tcoil3_mmw" "od" "80u" )
CCSchangeParam( "tcoil" "tcoil_master" "schematic" "tcoil3_mmw" "w" "2.4u" )
CCSchangeParam( "tcoil" "tcoil_master" "schematic" "tcoil3_mmw" "neo" "4" )
CCSchangeParam( "tcoil" "tcoil_master" "schematic" "tcoil3_mmw" "nei" "5" )
lxGenFromSource( cv_schematic )
cv_layout = dbOpenCellViewByType("tcoil" "tcoil_master" "layout")
MovePinsToInstances( cv_schematic cv_layout )
StreamOutGDS("tcoil" "tcoil_master" "layout" "/autofs/fs1.ece/fs1.eecg.tcc/lizongh2/gf22x-1020b/EMX_work/tcoil_tcoil2905.work" "tcoil2905.gds")

cv_schematic = dbOpenCellViewByType("tcoil" "tcoil_master" "schematic")
CCSchangeParam( "tcoil" "tcoil_master" "schematic" "tcoil3_mmw" "pneo" "60" )
CCSchangeParam( "tcoil" "tcoil_master" "schematic" "tcoil3_mmw" "ctapLocation" "bot" )
CCSchangeParam( "tcoil" "tcoil_master" "schematic" "tcoil3_mmw" "od" "80u" )
CCSchangeParam( "tcoil" "tcoil_master" "schematic" "tcoil3_mmw" "w" "2.4u" )
CCSchangeParam( "tcoil" "tcoil_master" "schematic" "tcoil3_mmw" "neo" "6" )
CCSchangeParam( "tcoil" "tcoil_master" "schematic" "tcoil3_mmw" "nei" "5" )
lxGenFromSource( cv_schematic )
cv_layout = dbOpenCellViewByType("tcoil" "tcoil_master" "layout")
MovePinsToInstances( cv_schematic cv_layout )
StreamOutGDS("tcoil" "tcoil_master" "layout" "/autofs/fs1.ece/fs1.eecg.tcc/lizongh2/gf22x-1020b/EMX_work/tcoil_tcoil2906.work" "tcoil2906.gds")

cv_schematic = dbOpenCellViewByType("tcoil" "tcoil_master" "schematic")
CCSchangeParam( "tcoil" "tcoil_master" "schematic" "tcoil3_mmw" "pneo" "60" )
CCSchangeParam( "tcoil" "tcoil_master" "schematic" "tcoil3_mmw" "ctapLocation" "bot" )
CCSchangeParam( "tcoil" "tcoil_master" "schematic" "tcoil3_mmw" "od" "80u" )
CCSchangeParam( "tcoil" "tcoil_master" "schematic" "tcoil3_mmw" "w" "2.4u" )
CCSchangeParam( "tcoil" "tcoil_master" "schematic" "tcoil3_mmw" "neo" "8" )
CCSchangeParam( "tcoil" "tcoil_master" "schematic" "tcoil3_mmw" "nei" "5" )
lxGenFromSource( cv_schematic )
cv_layout = dbOpenCellViewByType("tcoil" "tcoil_master" "layout")
MovePinsToInstances( cv_schematic cv_layout )
StreamOutGDS("tcoil" "tcoil_master" "layout" "/autofs/fs1.ece/fs1.eecg.tcc/lizongh2/gf22x-1020b/EMX_work/tcoil_tcoil2907.work" "tcoil2907.gds")

cv_schematic = dbOpenCellViewByType("tcoil" "tcoil_master" "schematic")
CCSchangeParam( "tcoil" "tcoil_master" "schematic" "tcoil3_mmw" "pneo" "60" )
CCSchangeParam( "tcoil" "tcoil_master" "schematic" "tcoil3_mmw" "ctapLocation" "bot" )
CCSchangeParam( "tcoil" "tcoil_master" "schematic" "tcoil3_mmw" "od" "80u" )
CCSchangeParam( "tcoil" "tcoil_master" "schematic" "tcoil3_mmw" "w" "2.4u" )
CCSchangeParam( "tcoil" "tcoil_master" "schematic" "tcoil3_mmw" "neo" "10" )
CCSchangeParam( "tcoil" "tcoil_master" "schematic" "tcoil3_mmw" "nei" "5" )
lxGenFromSource( cv_schematic )
cv_layout = dbOpenCellViewByType("tcoil" "tcoil_master" "layout")
MovePinsToInstances( cv_schematic cv_layout )
StreamOutGDS("tcoil" "tcoil_master" "layout" "/autofs/fs1.ece/fs1.eecg.tcc/lizongh2/gf22x-1020b/EMX_work/tcoil_tcoil2908.work" "tcoil2908.gds")

cv_schematic = dbOpenCellViewByType("tcoil" "tcoil_master" "schematic")
CCSchangeParam( "tcoil" "tcoil_master" "schematic" "tcoil3_mmw" "pneo" "60" )
CCSchangeParam( "tcoil" "tcoil_master" "schematic" "tcoil3_mmw" "ctapLocation" "bot" )
CCSchangeParam( "tcoil" "tcoil_master" "schematic" "tcoil3_mmw" "od" "80u" )
CCSchangeParam( "tcoil" "tcoil_master" "schematic" "tcoil3_mmw" "w" "2.4u" )
CCSchangeParam( "tcoil" "tcoil_master" "schematic" "tcoil3_mmw" "neo" "12" )
CCSchangeParam( "tcoil" "tcoil_master" "schematic" "tcoil3_mmw" "nei" "5" )
lxGenFromSource( cv_schematic )
cv_layout = dbOpenCellViewByType("tcoil" "tcoil_master" "layout")
MovePinsToInstances( cv_schematic cv_layout )
StreamOutGDS("tcoil" "tcoil_master" "layout" "/autofs/fs1.ece/fs1.eecg.tcc/lizongh2/gf22x-1020b/EMX_work/tcoil_tcoil2909.work" "tcoil2909.gds")

cv_schematic = dbOpenCellViewByType("tcoil" "tcoil_master" "schematic")
CCSchangeParam( "tcoil" "tcoil_master" "schematic" "tcoil3_mmw" "pneo" "60" )
CCSchangeParam( "tcoil" "tcoil_master" "schematic" "tcoil3_mmw" "ctapLocation" "bot" )
CCSchangeParam( "tcoil" "tcoil_master" "schematic" "tcoil3_mmw" "od" "80u" )
CCSchangeParam( "tcoil" "tcoil_master" "schematic" "tcoil3_mmw" "w" "4.2u" )
CCSchangeParam( "tcoil" "tcoil_master" "schematic" "tcoil3_mmw" "neo" "4" )
CCSchangeParam( "tcoil" "tcoil_master" "schematic" "tcoil3_mmw" "nei" "5" )
lxGenFromSource( cv_schematic )
cv_layout = dbOpenCellViewByType("tcoil" "tcoil_master" "layout")
MovePinsToInstances( cv_schematic cv_layout )
StreamOutGDS("tcoil" "tcoil_master" "layout" "/autofs/fs1.ece/fs1.eecg.tcc/lizongh2/gf22x-1020b/EMX_work/tcoil_tcoil2910.work" "tcoil2910.gds")

cv_schematic = dbOpenCellViewByType("tcoil" "tcoil_master" "schematic")
CCSchangeParam( "tcoil" "tcoil_master" "schematic" "tcoil3_mmw" "pneo" "60" )
CCSchangeParam( "tcoil" "tcoil_master" "schematic" "tcoil3_mmw" "ctapLocation" "bot" )
CCSchangeParam( "tcoil" "tcoil_master" "schematic" "tcoil3_mmw" "od" "80u" )
CCSchangeParam( "tcoil" "tcoil_master" "schematic" "tcoil3_mmw" "w" "4.2u" )
CCSchangeParam( "tcoil" "tcoil_master" "schematic" "tcoil3_mmw" "neo" "6" )
CCSchangeParam( "tcoil" "tcoil_master" "schematic" "tcoil3_mmw" "nei" "5" )
lxGenFromSource( cv_schematic )
cv_layout = dbOpenCellViewByType("tcoil" "tcoil_master" "layout")
MovePinsToInstances( cv_schematic cv_layout )
StreamOutGDS("tcoil" "tcoil_master" "layout" "/autofs/fs1.ece/fs1.eecg.tcc/lizongh2/gf22x-1020b/EMX_work/tcoil_tcoil2911.work" "tcoil2911.gds")

cv_schematic = dbOpenCellViewByType("tcoil" "tcoil_master" "schematic")
CCSchangeParam( "tcoil" "tcoil_master" "schematic" "tcoil3_mmw" "pneo" "60" )
CCSchangeParam( "tcoil" "tcoil_master" "schematic" "tcoil3_mmw" "ctapLocation" "bot" )
CCSchangeParam( "tcoil" "tcoil_master" "schematic" "tcoil3_mmw" "od" "80u" )
CCSchangeParam( "tcoil" "tcoil_master" "schematic" "tcoil3_mmw" "w" "4.2u" )
CCSchangeParam( "tcoil" "tcoil_master" "schematic" "tcoil3_mmw" "neo" "8" )
CCSchangeParam( "tcoil" "tcoil_master" "schematic" "tcoil3_mmw" "nei" "5" )
lxGenFromSource( cv_schematic )
cv_layout = dbOpenCellViewByType("tcoil" "tcoil_master" "layout")
MovePinsToInstances( cv_schematic cv_layout )
StreamOutGDS("tcoil" "tcoil_master" "layout" "/autofs/fs1.ece/fs1.eecg.tcc/lizongh2/gf22x-1020b/EMX_work/tcoil_tcoil2912.work" "tcoil2912.gds")

cv_schematic = dbOpenCellViewByType("tcoil" "tcoil_master" "schematic")
CCSchangeParam( "tcoil" "tcoil_master" "schematic" "tcoil3_mmw" "pneo" "60" )
CCSchangeParam( "tcoil" "tcoil_master" "schematic" "tcoil3_mmw" "ctapLocation" "bot" )
CCSchangeParam( "tcoil" "tcoil_master" "schematic" "tcoil3_mmw" "od" "80u" )
CCSchangeParam( "tcoil" "tcoil_master" "schematic" "tcoil3_mmw" "w" "4.2u" )
CCSchangeParam( "tcoil" "tcoil_master" "schematic" "tcoil3_mmw" "neo" "10" )
CCSchangeParam( "tcoil" "tcoil_master" "schematic" "tcoil3_mmw" "nei" "5" )
lxGenFromSource( cv_schematic )
cv_layout = dbOpenCellViewByType("tcoil" "tcoil_master" "layout")
MovePinsToInstances( cv_schematic cv_layout )
StreamOutGDS("tcoil" "tcoil_master" "layout" "/autofs/fs1.ece/fs1.eecg.tcc/lizongh2/gf22x-1020b/EMX_work/tcoil_tcoil2913.work" "tcoil2913.gds")

cv_schematic = dbOpenCellViewByType("tcoil" "tcoil_master" "schematic")
CCSchangeParam( "tcoil" "tcoil_master" "schematic" "tcoil3_mmw" "pneo" "60" )
CCSchangeParam( "tcoil" "tcoil_master" "schematic" "tcoil3_mmw" "ctapLocation" "bot" )
CCSchangeParam( "tcoil" "tcoil_master" "schematic" "tcoil3_mmw" "od" "80u" )
CCSchangeParam( "tcoil" "tcoil_master" "schematic" "tcoil3_mmw" "w" "4.2u" )
CCSchangeParam( "tcoil" "tcoil_master" "schematic" "tcoil3_mmw" "neo" "12" )
CCSchangeParam( "tcoil" "tcoil_master" "schematic" "tcoil3_mmw" "nei" "5" )
lxGenFromSource( cv_schematic )
cv_layout = dbOpenCellViewByType("tcoil" "tcoil_master" "layout")
MovePinsToInstances( cv_schematic cv_layout )
StreamOutGDS("tcoil" "tcoil_master" "layout" "/autofs/fs1.ece/fs1.eecg.tcc/lizongh2/gf22x-1020b/EMX_work/tcoil_tcoil2914.work" "tcoil2914.gds")

cv_schematic = dbOpenCellViewByType("tcoil" "tcoil_master" "schematic")
CCSchangeParam( "tcoil" "tcoil_master" "schematic" "tcoil3_mmw" "pneo" "60" )
CCSchangeParam( "tcoil" "tcoil_master" "schematic" "tcoil3_mmw" "ctapLocation" "bot" )
CCSchangeParam( "tcoil" "tcoil_master" "schematic" "tcoil3_mmw" "od" "80u" )
CCSchangeParam( "tcoil" "tcoil_master" "schematic" "tcoil3_mmw" "w" "5.0u" )
CCSchangeParam( "tcoil" "tcoil_master" "schematic" "tcoil3_mmw" "neo" "4" )
CCSchangeParam( "tcoil" "tcoil_master" "schematic" "tcoil3_mmw" "nei" "5" )
lxGenFromSource( cv_schematic )
cv_layout = dbOpenCellViewByType("tcoil" "tcoil_master" "layout")
MovePinsToInstances( cv_schematic cv_layout )
StreamOutGDS("tcoil" "tcoil_master" "layout" "/autofs/fs1.ece/fs1.eecg.tcc/lizongh2/gf22x-1020b/EMX_work/tcoil_tcoil2915.work" "tcoil2915.gds")

cv_schematic = dbOpenCellViewByType("tcoil" "tcoil_master" "schematic")
CCSchangeParam( "tcoil" "tcoil_master" "schematic" "tcoil3_mmw" "pneo" "60" )
CCSchangeParam( "tcoil" "tcoil_master" "schematic" "tcoil3_mmw" "ctapLocation" "bot" )
CCSchangeParam( "tcoil" "tcoil_master" "schematic" "tcoil3_mmw" "od" "80u" )
CCSchangeParam( "tcoil" "tcoil_master" "schematic" "tcoil3_mmw" "w" "5.0u" )
CCSchangeParam( "tcoil" "tcoil_master" "schematic" "tcoil3_mmw" "neo" "6" )
CCSchangeParam( "tcoil" "tcoil_master" "schematic" "tcoil3_mmw" "nei" "5" )
lxGenFromSource( cv_schematic )
cv_layout = dbOpenCellViewByType("tcoil" "tcoil_master" "layout")
MovePinsToInstances( cv_schematic cv_layout )
StreamOutGDS("tcoil" "tcoil_master" "layout" "/autofs/fs1.ece/fs1.eecg.tcc/lizongh2/gf22x-1020b/EMX_work/tcoil_tcoil2916.work" "tcoil2916.gds")

cv_schematic = dbOpenCellViewByType("tcoil" "tcoil_master" "schematic")
CCSchangeParam( "tcoil" "tcoil_master" "schematic" "tcoil3_mmw" "pneo" "60" )
CCSchangeParam( "tcoil" "tcoil_master" "schematic" "tcoil3_mmw" "ctapLocation" "bot" )
CCSchangeParam( "tcoil" "tcoil_master" "schematic" "tcoil3_mmw" "od" "80u" )
CCSchangeParam( "tcoil" "tcoil_master" "schematic" "tcoil3_mmw" "w" "5.0u" )
CCSchangeParam( "tcoil" "tcoil_master" "schematic" "tcoil3_mmw" "neo" "8" )
CCSchangeParam( "tcoil" "tcoil_master" "schematic" "tcoil3_mmw" "nei" "5" )
lxGenFromSource( cv_schematic )
cv_layout = dbOpenCellViewByType("tcoil" "tcoil_master" "layout")
MovePinsToInstances( cv_schematic cv_layout )
StreamOutGDS("tcoil" "tcoil_master" "layout" "/autofs/fs1.ece/fs1.eecg.tcc/lizongh2/gf22x-1020b/EMX_work/tcoil_tcoil2917.work" "tcoil2917.gds")

cv_schematic = dbOpenCellViewByType("tcoil" "tcoil_master" "schematic")
CCSchangeParam( "tcoil" "tcoil_master" "schematic" "tcoil3_mmw" "pneo" "60" )
CCSchangeParam( "tcoil" "tcoil_master" "schematic" "tcoil3_mmw" "ctapLocation" "bot" )
CCSchangeParam( "tcoil" "tcoil_master" "schematic" "tcoil3_mmw" "od" "80u" )
CCSchangeParam( "tcoil" "tcoil_master" "schematic" "tcoil3_mmw" "w" "5.0u" )
CCSchangeParam( "tcoil" "tcoil_master" "schematic" "tcoil3_mmw" "neo" "10" )
CCSchangeParam( "tcoil" "tcoil_master" "schematic" "tcoil3_mmw" "nei" "5" )
lxGenFromSource( cv_schematic )
cv_layout = dbOpenCellViewByType("tcoil" "tcoil_master" "layout")
MovePinsToInstances( cv_schematic cv_layout )
StreamOutGDS("tcoil" "tcoil_master" "layout" "/autofs/fs1.ece/fs1.eecg.tcc/lizongh2/gf22x-1020b/EMX_work/tcoil_tcoil2918.work" "tcoil2918.gds")

cv_schematic = dbOpenCellViewByType("tcoil" "tcoil_master" "schematic")
CCSchangeParam( "tcoil" "tcoil_master" "schematic" "tcoil3_mmw" "pneo" "60" )
CCSchangeParam( "tcoil" "tcoil_master" "schematic" "tcoil3_mmw" "ctapLocation" "bot" )
CCSchangeParam( "tcoil" "tcoil_master" "schematic" "tcoil3_mmw" "od" "80u" )
CCSchangeParam( "tcoil" "tcoil_master" "schematic" "tcoil3_mmw" "w" "5.0u" )
CCSchangeParam( "tcoil" "tcoil_master" "schematic" "tcoil3_mmw" "neo" "12" )
CCSchangeParam( "tcoil" "tcoil_master" "schematic" "tcoil3_mmw" "nei" "5" )
lxGenFromSource( cv_schematic )
cv_layout = dbOpenCellViewByType("tcoil" "tcoil_master" "layout")
MovePinsToInstances( cv_schematic cv_layout )
StreamOutGDS("tcoil" "tcoil_master" "layout" "/autofs/fs1.ece/fs1.eecg.tcc/lizongh2/gf22x-1020b/EMX_work/tcoil_tcoil2919.work" "tcoil2919.gds")
